# Ansys Electronics Desktop project, version 2025.1
materials:
  TDK_PC95_60cel_BH: core_loss_curve{50kHz (0, 0) (0.049862966, 4.1005345) (0.060258577, 6.8639779) (0.069693025, 9.604843) (0.079288168, 12.85137) (0.089957123, 17.195253) (0.10011968, 22.497801) (0.13429265, 48.181396) (0.19992957, 126.23138) (0.24094943, 202.0447) (0.30010796, 361.71437)} core_loss_curve{100kHz (0, 0) (0.05, 11.750028) (0.059928731, 18.390411) (0.069311536, 26.316823) (0.079506068, 36.825433) (0.090204344, 49.272773) (0.10039483, 64.467157) (0.12000091, 98.665069) (0.15876613, 193.19337) (0.19938163, 330.71604) (0.23897376, 506.15107) (0.29928546, 906.14655)} core_loss_curve{200kHz (0, 0) (0.05, 31.481432) (0.060258577, 50.388871) (0.069693025, 68.947957) (0.079724568, 96.479667) (0.089957123, 129.0907) (0.10067074, 172.72456) (0.13765098, 386.85538) (0.20047902, 947.6625) (0.2490168, 1586.3138) (0.29928546, 2482.7994)} core_loss_curve{300kHz (0, 0) (0.049862966, 63.039229) (0.060093428, 100.89997) (0.069502019, 144.38866) (0.079724568, 197.56947) (0.08971058, 264.3498) (0.10039483, 345.8681) (0.12712013, 605.4819) (0.15446813, 991.08054) (0.19883519, 1897.6238) (0.23963051, 2904.2568) (0.30093272, 4861.5015)} permeability{HUnit=A_per_meter BUnit=tesla curve (0, 0) (17.20430108, 0.079976243) (32.49701314, 0.199539595) (49.70131422, 0.297790055) (64.09402628, 0.349834622) (76.46356033, 0.383911602) (89.84468339, 0.412285451) (107.0489845, 0.436556169) (135.7228196, 0.45174954) (168.2198327, 0.462891344) (202.6284349, 0.471007366) (250.4181601, 0.478084715) (298.2078853, 0.481123389) (498.9247312, 0.486187845) (1282.676225, 0.491252302) (2560, 0.4934)} conductivity=0.167 saturation_mag=0.48tesla core_loss_type="Power Ferrite" core_loss_cm=0.59673882 core_loss_x=1.4941961 core_loss_y=2.4413048 mass_density=4900
  copper_lizt_c_1: permeability=0.999991 conductivity=58000000 stacking_type="Litz Wire" wire_type=Square strand_number=100 wire_width=0.1mm litz_wire_twisting_length_factor=1.1
  copper_lizt_c_1.5: permeability=0.999991 conductivity=58000000 stacking_type="Litz Wire" wire_type=Square strand_number=225 wire_width=0.1mm litz_wire_twisting_length_factor=1.1
  copper_lizt_c_2: permeability=0.999991 conductivity=58000000 stacking_type="Litz Wire" wire_type=Square strand_number=400 wire_width=0.1mm litz_wire_twisting_length_factor=1.1
  copper_lizt_c_2.5: permeability=0.999991 conductivity=58000000 stacking_type="Litz Wire" wire_type=Square strand_number=625 wire_width=0.1mm litz_wire_twisting_length_factor=1.1
  copper_lizt_c_3: permeability=0.999991 conductivity=58000000 stacking_type="Litz Wire" wire_type=Square strand_number=900 wire_width=0.1mm litz_wire_twisting_length_factor=1.1
  copper_lizt_c_3.5: permeability=0.999991 conductivity=58000000 stacking_type="Litz Wire" wire_type=Square strand_number=1225 wire_width=0.1mm litz_wire_twisting_length_factor=1.1
  copper_lizt_c_4: permeability=0.999991 conductivity=58000000 stacking_type="Litz Wire" wire_type=Square strand_number=1600 wire_width=0.1mm litz_wire_twisting_length_factor=1.1
  copper_lizt_c_4.5: permeability=0.999991 conductivity=58000000 stacking_type="Litz Wire" wire_type=Square strand_number=2025 wire_width=0.1mm litz_wire_twisting_length_factor=1.1
  copper_lizt_c_5: permeability=0.999991 conductivity=58000000 stacking_type="Litz Wire" wire_type=Square strand_number=2500 wire_width=0.1mm litz_wire_twisting_length_factor=1.1
  vacuum: permittivity=1

design Test1_500 (Maxwell 3D, EddyCurrent, model units mm)
variables:
  dc1 = 15mm
  Nx = 3
  Ny = 5
  c = 3mm
  f = 400kHz
  dc2 = 5mm
  ht = 5mm
  lg1 = 0.6mm
  i = 9A
  dwc = 0.7mm
  mathindex = index ArrayVarName='lizt_sweep' into 4
  N = 0
  lizt_sweep = ["copper_lizt_c_1", "copper_lizt_c_1.5", "copper_lizt_c_2", "copper_lizt_c_2.5", "copper_lizt_c_3", "copper_lizt_c_3.5", "copper_lizt_c_4", "copper_lizt_c_4.5", "copper_lizt_c_5"]
geometry:
  core_center = cylinder(axis=Z, base_centre=(0mm, 0mm, -lg1/4), radius=dc1/2, height=-(Ny*c/2+dwc))
  Box1 = box(corner=(-(dc1/2+2*dwc+Nx*c+dc2), dc1/2, -(Ny*c+2*dwc)/2), size=(2*(dc1/2+2*dwc+Nx*c+dc2), -dc1, -ht))
  Box2 = box(corner=(-(dc1/2+2*dwc+Nx*c+dc2), dc1/2, -(Ny*c+2*dwc)/2), size=(dc2, -dc1, (Ny*c+2*dwc)/2-lg1/4))
  Box2_1 = Box2.duplicate_mirror(point=(0mm, 0mm, 0mm), normal=(1mm, 0mm, 0mm))
  core_center.unite(Box1, Box2, Box2_1)
  core_center_1 [TDK_PC95_60cel_BH] = core_center.duplicate_mirror(point=(0mm, 0mm, 0mm), normal=(0mm, 0mm, 1mm))
  P [lizt_sweep[mathindex]] = rectangle(corner=(dc1/2+dwc, 0mm, -Ny*c/2), z_size=Ny*c, x_size=Nx*c)
  P.sweep_around_axis(axis=Z, angle=360deg)
  Region [vacuum] = region(percentage_offset: +X=100, -X=0, +Y=100, -Y=0, +Z=100, -Z=0)
  [core_center, core_center_1, P].split(plane=ZX, keep=PositiveOnly)
  [core_center, core_center_1, P].split(plane=YZ, keep=PositiveOnly)
  core_center.split(plane=XY, keep=PositiveOnly)
  core_center.delete()
  [core_center_1, P].split(plane=XY, keep=PositiveOnly)
boundaries and excitations:
  Symmetry1: Symmetry Faces=Region.face(-y, -x) IsOdd=true
  Symmetry2: Symmetry Faces=Region.face(-z) IsOdd=false
  CoilTerminal1: Coil Terminal Faces=P.face(at (12.7, 0, 3.75)) Conductor_number=Nx*Ny/2 Winding=Winding1 Point_out_of_terminal=false
  CoilTerminal2: Coil Terminal Faces=P.face(at (0, 12.7, 3.75)) Conductor_number=Nx*Ny/2 Winding=Winding1 Point_out_of_terminal=true
  Winding1: Winding Group Type=Current IsSolid=false Current=i ParallelBranchesNum=1 Phase=0deg
  eddy effects on: P
  core loss on: core_center_1
parameters:
  Matrix1: Matrix Winding1:
mesh:
  initial mesh: GlobalCurvilinear{Apply}
setups:
  Setup1: EddyCurrent MaximumPasses=10 MinimumPasses=2 MinimumConvergedPasses=1 PercentRefinement=60 PercentError=2 NonLinearResidual=0.0001 Frequency=f LossAdaptiveCtrl=0.5
optimetrics:
  filtered_samples_2000_1: Parametric Sim._Setups=[Setup1]
    sweep dc1: 21.1mm
    sweep Nx: 3
    sweep Ny: 3
    sweep c: 4.0mm
    sweep f: 150.0kHz
    sweep dc2: 10.4mm
    sweep ht: 11.0mm
    sweep lg1: 2.5mm
    sweep i: 48.0A
    sweep mathindex: 6
    table edits: add(21.8mm, 4, 1, 4.0mm, 350.0kHz, 12.8mm, 11.2mm, 2.5mm, 48.0A, 6) add(28.1mm, 5, 4, 3.5mm, 250.0kHz, 16.5mm, 14.7mm, 3.4mm, 36.0A, 5) add(23.9mm, 2, 2, 4.0mm, 450.0kHz, 8.2mm, 6.1mm, 1.3mm, 48.0A, 6) add(19.0mm, 2, 1, 5.0mm, 350.0kHz, 9.4mm, 6.4mm, 3.7mm, 45.0A, 8) add(28.1mm, 3, 3, 3.5mm, 350.0kHz, 5.3mm, 6.3mm, 2.8mm, 33.0A, 5) add(28.8mm, 3, 4, 3.5mm, 350.0kHz, 16.6mm, 12.1mm, 2.8mm, 45.0A, 5) add(19.0mm, 1, 2, 4.5mm, 250.0kHz, 1.4mm, 5.0mm, 0.7mm, 45.0A, 7) add(23.9mm, 5, 4, 3.5mm, 450.0kHz, 5.0mm, 12.4mm, 2.8mm, 30.0A, 5) add(18.3mm, 4, 3, 4.5mm, 350.0kHz, 9.4mm, 5.5mm, 2.8mm, 30.0A, 7) add(22.5mm, 4, 1, 4.0mm, 450.0kHz, 4.9mm, 9.3mm, 1.0mm, 42.0A, 6) add(27.4mm, 2, 1, 4.5mm, 150.0kHz, 10.9mm, 11.1mm, 3.1mm, 45.0A, 7) add(23.2mm, 3, 1, 4.0mm, 350.0kHz, 2.5mm, 5.2mm, 2.8mm, 36.0A, 6) add(29.5mm, 4, 2, 4.5mm, 250.0kHz, 6.2mm, 9.4mm, 3.4mm, 33.0A, 7) add(23.2mm, 3, 4, 3.5mm, 150.0kHz, 8.9mm, 12.2mm, 2.8mm, 42.0A, 5) add(24.6mm, 1, 4, 4.5mm, 150.0kHz, 7.4mm, 11.8mm, 1.0mm, 33.0A, 7) add(19.0mm, 1, 3, 4.5mm, 150.0kHz, 8.6mm, 11.3mm, 1.9mm, 42.0A, 7) add(26.7mm, 3, 3, 5.0mm, 350.0kHz, 11.6mm, 8.1mm, 1.9mm, 36.0A, 8) add(14.1mm, 1, 3, 5.0mm, 150.0kHz, 5.1mm, 8.8mm, 3.1mm, 30.0A, 8) add(23.2mm, 3, 1, 4.5mm, 450.0kHz, 4.9mm, 11.5mm, 1.3mm, 45.0A, 7) add(18.3mm, 1, 4, 3.5mm, 350.0kHz, 1.4mm, 11.1mm, 2.8mm, 30.0A, 5) add(26.7mm, 2, 3, 3.5mm, 250.0kHz, 2.8mm, 9.5mm, 3.7mm, 48.0A, 5) add(21.8mm, 1, 1, 5.0mm, 450.0kHz, 3.2mm, 7.0mm, 3.1mm, 42.0A, 8) add(21.1mm, 4, 2, 3.5mm, 150.0kHz, 8.8mm, 9.6mm, 1.9mm, 39.0A, 5) add(9.2mm, 3, 1, 4.0mm, 450.0kHz, 4.2mm, 2.1mm, 2.8mm, 42.0A, 6) add(15.5mm, 1, 2, 3.5mm, 450.0kHz, 8.4mm, 3.5mm, 2.5mm, 42.0A, 5) add(28.1mm, 4, 2, 4.5mm, 450.0kHz, 10.1mm, 16.8mm, 3.1mm, 36.0A, 7) add(28.1mm, 2, 1, 3.5mm, 150.0kHz, 4.5mm, 10.5mm, 2.5mm, 36.0A, 5) add(26.0mm, 1, 2, 4.5mm, 350.0kHz, 13.9mm, 12.8mm, 1.9mm, 33.0A, 7) add(29.5mm, 1, 5, 3.5mm, 350.0kHz, 13.4mm, 6.6mm, 2.5mm, 45.0A, 5) add(29.5mm, 1, 1, 4.0mm, 350.0kHz, 7.0mm, 12.2mm, 0.4mm, 39.0A, 6) add(27.4mm, 2, 2, 5.0mm, 150.0kHz, 14.1mm, 16.7mm, 2.2mm, 33.0A, 8) add(8.5mm, 4, 1, 4.0mm, 150.0kHz, 5.0mm, 4.7mm, 3.7mm, 45.0A, 6) add(17.6mm, 3, 3, 4.0mm, 250.0kHz, 6.1mm, 8.9mm, 2.2mm, 42.0A, 6) add(23.9mm, 4, 2, 3.5mm, 450.0kHz, 14.6mm, 8.2mm, 3.4mm, 36.0A, 5) add(19.0mm, 3, 2, 4.5mm, 350.0kHz, 7.8mm, 5.0mm, 3.7mm, 39.0A, 7) add(25.3mm, 3, 1, 4.5mm, 450.0kHz, 9.1mm, 15.5mm, 3.7mm, 45.0A, 7) add(19.0mm, 4, 2, 4.5mm, 250.0kHz, 7.8mm, 9.2mm, 3.7mm, 42.0A, 7) add(27.4mm, 2, 2, 3.5mm, 150.0kHz, 13.3mm, 13.9mm, 1.3mm, 42.0A, 5) add(18.3mm, 4, 2, 3.5mm, 150.0kHz, 1.4mm, 4.8mm, 3.1mm, 36.0A, 5) add(26.0mm, 2, 2, 5.0mm, 150.0kHz, 2.7mm, 10.0mm, 3.7mm, 48.0A, 8) add(9.9mm, 1, 2, 4.5mm, 150.0kHz, 2.6mm, 4.3mm, 1.9mm, 39.0A, 7) add(21.8mm, 2, 1, 3.5mm, 250.0kHz, 5.6mm, 6.3mm, 3.4mm, 30.0A, 5) add(21.8mm, 1, 1, 4.0mm, 450.0kHz, 11.2mm, 9.1mm, 1.0mm, 48.0A, 6) add(19.0mm, 2, 1, 5.0mm, 150.0kHz, 5.4mm, 5.0mm, 0.4mm, 30.0A, 8) add(25.3mm, 4, 2, 4.0mm, 150.0kHz, 13.9mm, 9.2mm, 3.1mm, 30.0A, 6) add(28.8mm, 2, 4, 4.0mm, 250.0kHz, 2.2mm, 13.5mm, 1.6mm, 30.0A, 6) add(23.2mm, 3, 4, 4.0mm, 250.0kHz, 10.5mm, 13.6mm, 3.4mm, 33.0A, 6) add(21.8mm, 1, 3, 4.0mm, 150.0kHz, 8.0mm, 12.6mm, 0.7mm, 42.0A, 6) add(28.1mm, 2, 4, 4.5mm, 250.0kHz, 2.9mm, 7.7mm, 2.2mm, 30.0A, 7) add(24.6mm, 2, 2, 4.0mm, 350.0kHz, 8.2mm, 8.3mm, 1.6mm, 39.0A, 6) add(26.7mm, 1, 4, 3.5mm, 250.0kHz, 10.0mm, 11.6mm, 1.0mm, 42.0A, 5) add(26.7mm, 1, 1, 5.0mm, 250.0kHz, 16.4mm, 7.4mm, 2.2mm, 45.0A, 8) add(19.7mm, 4, 1, 4.0mm, 150.0kHz, 3.9mm, 9.3mm, 2.5mm, 33.0A, 6) add(27.4mm, 1, 2, 5.0mm, 350.0kHz, 4.5mm, 10.4mm, 1.3mm, 45.0A, 8) add(29.5mm, 5, 2, 3.5mm, 450.0kHz, 2.2mm, 8.0mm, 3.1mm, 45.0A, 5) add(9.9mm, 2, 2, 5.0mm, 350.0kHz, 5.8mm, 4.3mm, 2.2mm, 45.0A, 8) add(17.6mm, 2, 3, 4.0mm, 450.0kHz, 9.3mm, 7.5mm, 1.9mm, 48.0A, 6) add(28.8mm, 4, 1, 3.5mm, 450.0kHz, 16.6mm, 16.3mm, 2.5mm, 30.0A, 5) add(27.4mm, 2, 2, 4.0mm, 450.0kHz, 2.1mm, 13.2mm, 1.3mm, 42.0A, 6) add(10.6mm, 3, 3, 3.5mm, 450.0kHz, 1.0mm, 3.8mm, 3.7mm, 42.0A, 5)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
  filtered_samples_2000_2: Parametric Sim._Setups=[Setup1]
    sweep dc1: 27.4mm
    sweep Nx: 1
    sweep Ny: 1
    sweep c: 3.5mm
    sweep f: 450.0kHz
    sweep dc2: 5.3mm
    sweep ht: 8.3mm
    sweep lg1: 1.9mm
    sweep i: 39.0A
    sweep mathindex: 5
    table edits: add(18.3mm, 5, 1, 3.5mm, 150.0kHz, 11.0mm, 10.4mm, 2.2mm, 30.0A, 5) add(20.4mm, 1, 1, 5.0mm, 250.0kHz, 7.1mm, 5.3mm, 0.4mm, 33.0A, 8) add(26.7mm, 4, 1, 4.0mm, 250.0kHz, 3.6mm, 14.4mm, 3.7mm, 36.0A, 6) add(21.1mm, 1, 1, 4.5mm, 450.0kHz, 9.6mm, 6.8mm, 1.9mm, 45.0A, 7) add(14.1mm, 3, 1, 3.5mm, 150.0kHz, 6.7mm, 4.6mm, 2.8mm, 33.0A, 5) add(28.8mm, 3, 1, 4.5mm, 350.0kHz, 3.8mm, 11.4mm, 3.4mm, 45.0A, 7) add(24.6mm, 2, 1, 4.5mm, 150.0kHz, 3.4mm, 13.9mm, 2.5mm, 33.0A, 7) add(25.3mm, 4, 2, 4.0mm, 350.0kHz, 9.9mm, 7.8mm, 3.7mm, 48.0A, 6) add(26.7mm, 5, 3, 3.5mm, 250.0kHz, 10.8mm, 13.0mm, 3.7mm, 39.0A, 5) add(18.3mm, 4, 1, 4.0mm, 450.0kHz, 5.4mm, 11.1mm, 3.4mm, 30.0A, 6) add(28.1mm, 3, 3, 4.5mm, 250.0kHz, 15.7mm, 6.3mm, 2.5mm, 30.0A, 7) add(26.7mm, 2, 2, 4.0mm, 350.0kHz, 2.0mm, 8.8mm, 1.6mm, 33.0A, 6) add(17.6mm, 1, 4, 4.0mm, 150.0kHz, 9.3mm, 4.7mm, 3.7mm, 33.0A, 6) add(19.0mm, 4, 3, 3.5mm, 450.0kHz, 10.2mm, 10.6mm, 2.5mm, 33.0A, 5) add(15.5mm, 1, 4, 4.5mm, 250.0kHz, 2.0mm, 9.1mm, 1.3mm, 30.0A, 7) add(17.6mm, 1, 3, 4.0mm, 150.0kHz, 6.9mm, 5.4mm, 1.9mm, 39.0A, 6) add(23.9mm, 2, 2, 3.5mm, 350.0kHz, 10.6mm, 13.8mm, 3.4mm, 30.0A, 5) add(14.1mm, 3, 1, 4.5mm, 350.0kHz, 1.9mm, 6.0mm, 1.3mm, 45.0A, 7) add(25.3mm, 2, 1, 4.5mm, 350.0kHz, 11.5mm, 10.6mm, 2.2mm, 33.0A, 7) add(10.6mm, 3, 2, 5.0mm, 150.0kHz, 1.0mm, 2.4mm, 3.4mm, 30.0A, 8) add(28.1mm, 2, 4, 3.5mm, 150.0kHz, 7.7mm, 9.1mm, 1.6mm, 30.0A, 5) add(16.2mm, 2, 3, 5.0mm, 250.0kHz, 6.0mm, 5.0mm, 2.5mm, 42.0A, 8) add(28.8mm, 2, 2, 3.5mm, 350.0kHz, 2.2mm, 6.5mm, 3.4mm, 33.0A, 5) add(15.5mm, 5, 3, 3.5mm, 250.0kHz, 5.2mm, 4.9mm, 1.9mm, 30.0A, 5) add(12.7mm, 2, 2, 4.0mm, 150.0kHz, 5.8mm, 5.7mm, 3.4mm, 39.0A, 6) add(12.0mm, 4, 3, 4.0mm, 450.0kHz, 1.8mm, 2.7mm, 3.4mm, 39.0A, 6) add(16.9mm, 2, 4, 4.5mm, 150.0kHz, 5.3mm, 3.8mm, 2.2mm, 30.0A, 7) add(11.3mm, 1, 4, 4.5mm, 350.0kHz, 5.8mm, 2.5mm, 2.8mm, 45.0A, 7) add(17.6mm, 4, 1, 3.5mm, 150.0kHz, 1.3mm, 4.0mm, 1.0mm, 30.0A, 5) add(20.4mm, 3, 2, 5.0mm, 150.0kHz, 6.3mm, 10.9mm, 1.9mm, 36.0A, 8) add(14.8mm, 3, 1, 4.0mm, 350.0kHz, 5.9mm, 4.7mm, 0.7mm, 42.0A, 6) add(29.5mm, 2, 1, 4.0mm, 350.0kHz, 14.2mm, 13.6mm, 0.4mm, 33.0A, 6) add(22.5mm, 3, 1, 5.0mm, 250.0kHz, 8.9mm, 6.5mm, 1.6mm, 33.0A, 8) add(21.1mm, 3, 1, 3.5mm, 250.0kHz, 8.0mm, 6.1mm, 1.3mm, 39.0A, 5) add(21.8mm, 4, 1, 4.0mm, 450.0kHz, 10.4mm, 9.8mm, 1.3mm, 30.0A, 6) add(19.7mm, 1, 4, 4.0mm, 250.0kHz, 1.5mm, 7.2mm, 2.5mm, 42.0A, 6) add(18.3mm, 1, 5, 3.5mm, 250.0kHz, 5.4mm, 9.0mm, 3.7mm, 36.0A, 5) add(29.5mm, 2, 2, 5.0mm, 350.0kHz, 9.4mm, 7.3mm, 2.5mm, 36.0A, 8) add(16.9mm, 1, 3, 4.5mm, 250.0kHz, 3.7mm, 4.5mm, 2.8mm, 42.0A, 7) add(25.3mm, 1, 2, 3.5mm, 350.0kHz, 1.9mm, 10.6mm, 3.4mm, 48.0A, 5) add(20.4mm, 3, 2, 4.0mm, 150.0kHz, 11.9mm, 9.5mm, 1.0mm, 36.0A, 6) add(21.1mm, 1, 4, 4.0mm, 250.0kHz, 11.2mm, 8.9mm, 1.0mm, 39.0A, 6) add(28.1mm, 3, 2, 5.0mm, 150.0kHz, 7.7mm, 15.4mm, 3.1mm, 39.0A, 8) add(26.0mm, 1, 2, 3.5mm, 150.0kHz, 12.3mm, 10.0mm, 3.4mm, 36.0A, 5) add(28.8mm, 4, 1, 4.0mm, 450.0kHz, 16.6mm, 10.0mm, 2.2mm, 36.0A, 6) add(19.0mm, 5, 1, 3.5mm, 450.0kHz, 5.4mm, 10.6mm, 3.4mm, 33.0A, 5) add(21.1mm, 2, 1, 4.5mm, 450.0kHz, 7.2mm, 8.9mm, 2.2mm, 30.0A, 7) add(15.5mm, 2, 1, 3.5mm, 450.0kHz, 9.2mm, 4.9mm, 2.2mm, 39.0A, 5) add(17.6mm, 1, 1, 3.5mm, 350.0kHz, 5.3mm, 4.0mm, 1.0mm, 48.0A, 5) add(23.2mm, 4, 1, 4.0mm, 250.0kHz, 6.5mm, 5.9mm, 2.2mm, 45.0A, 6) add(14.8mm, 4, 1, 4.0mm, 150.0kHz, 4.3mm, 4.7mm, 2.2mm, 36.0A, 6) add(15.5mm, 1, 4, 4.5mm, 250.0kHz, 1.2mm, 4.9mm, 2.2mm, 42.0A, 7) add(28.1mm, 2, 3, 5.0mm, 250.0kHz, 13.3mm, 14.0mm, 1.0mm, 33.0A, 8) add(29.5mm, 1, 3, 5.0mm, 450.0kHz, 16.6mm, 17.1mm, 3.1mm, 33.0A, 8) add(26.7mm, 2, 2, 3.5mm, 350.0kHz, 14.8mm, 14.4mm, 3.1mm, 30.0A, 5) add(28.8mm, 4, 2, 4.5mm, 150.0kHz, 14.2mm, 11.4mm, 3.1mm, 33.0A, 7) add(25.3mm, 1, 3, 4.0mm, 250.0kHz, 11.5mm, 7.8mm, 3.7mm, 42.0A, 6) add(27.4mm, 2, 1, 4.0mm, 350.0kHz, 15.7mm, 13.2mm, 2.5mm, 42.0A, 6) add(25.3mm, 3, 1, 4.5mm, 350.0kHz, 3.5mm, 14.1mm, 3.1mm, 39.0A, 7) add(21.8mm, 4, 1, 3.5mm, 150.0kHz, 5.6mm, 7.7mm, 2.8mm, 48.0A, 5)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
  filtered_samples_2000_3: Parametric Sim._Setups=[Setup1]
    sweep dc1: 23.2mm
    sweep Nx: 1
    sweep Ny: 1
    sweep c: 4.5mm
    sweep f: 350.0kHz
    sweep dc2: 3.3mm
    sweep ht: 11.5mm
    sweep lg1: 3.1mm
    sweep i: 45.0A
    sweep mathindex: 7
    table edits: add(21.8mm, 3, 4, 3.5mm, 350.0kHz, 10.4mm, 11.2mm, 3.1mm, 48.0A, 5) add(16.9mm, 1, 3, 4.0mm, 250.0kHz, 5.3mm, 8.7mm, 3.7mm, 30.0A, 6) add(13.4mm, 4, 1, 4.5mm, 250.0kHz, 6.6mm, 5.1mm, 1.9mm, 33.0A, 7) add(28.8mm, 3, 1, 5.0mm, 150.0kHz, 15.8mm, 10.0mm, 2.8mm, 39.0A, 8) add(25.3mm, 3, 3, 3.5mm, 350.0kHz, 2.7mm, 10.6mm, 3.4mm, 42.0A, 5) add(17.6mm, 2, 2, 3.5mm, 450.0kHz, 2.1mm, 4.7mm, 0.7mm, 30.0A, 5) add(21.8mm, 3, 1, 3.5mm, 350.0kHz, 7.2mm, 8.4mm, 1.0mm, 36.0A, 5) add(7.8mm, 4, 4, 4.0mm, 150.0kHz, 3.4mm, 3.2mm, 2.5mm, 36.0A, 6) add(23.2mm, 2, 2, 3.5mm, 450.0kHz, 13.7mm, 12.9mm, 3.1mm, 48.0A, 5) add(28.8mm, 3, 3, 5.0mm, 350.0kHz, 13.4mm, 12.1mm, 3.4mm, 33.0A, 8) add(29.5mm, 3, 1, 4.0mm, 150.0kHz, 15.0mm, 9.4mm, 0.7mm, 39.0A, 6) add(16.9mm, 5, 1, 3.5mm, 250.0kHz, 1.3mm, 7.3mm, 2.2mm, 45.0A, 5) add(24.6mm, 5, 2, 3.5mm, 150.0kHz, 5.0mm, 11.8mm, 3.7mm, 36.0A, 5) add(16.9mm, 2, 4, 3.5mm, 150.0kHz, 6.1mm, 3.8mm, 2.8mm, 45.0A, 5) add(15.5mm, 1, 3, 4.5mm, 150.0kHz, 3.6mm, 7.7mm, 3.1mm, 33.0A, 7) add(24.6mm, 4, 1, 4.0mm, 150.0kHz, 6.6mm, 9.0mm, 0.7mm, 39.0A, 6) add(28.1mm, 3, 3, 3.5mm, 250.0kHz, 15.7mm, 7.0mm, 1.6mm, 30.0A, 5) add(29.5mm, 2, 2, 5.0mm, 350.0kHz, 10.2mm, 15.7mm, 1.9mm, 48.0A, 8) add(16.2mm, 2, 3, 4.5mm, 450.0kHz, 3.6mm, 5.7mm, 3.4mm, 36.0A, 7) add(28.8mm, 3, 3, 3.5mm, 150.0kHz, 10.2mm, 13.5mm, 1.9mm, 39.0A, 5) add(5.0mm, 3, 3, 3.5mm, 250.0kHz, 1.8mm, 1.1mm, 3.7mm, 36.0A, 5) add(28.1mm, 1, 1, 5.0mm, 450.0kHz, 7.7mm, 10.5mm, 1.6mm, 30.0A, 8) add(23.2mm, 1, 3, 4.0mm, 350.0kHz, 12.1mm, 12.9mm, 3.4mm, 33.0A, 6) add(26.0mm, 1, 2, 4.5mm, 450.0kHz, 13.1mm, 12.8mm, 1.6mm, 33.0A, 7) add(21.8mm, 2, 1, 5.0mm, 450.0kHz, 11.2mm, 7.0mm, 3.7mm, 33.0A, 8) add(12.0mm, 3, 2, 5.0mm, 350.0kHz, 5.0mm, 4.8mm, 1.9mm, 48.0A, 8) add(27.4mm, 5, 2, 3.5mm, 350.0kHz, 7.7mm, 9.7mm, 1.9mm, 30.0A, 5) add(28.1mm, 4, 3, 3.5mm, 350.0kHz, 14.9mm, 7.7mm, 2.2mm, 42.0A, 5) add(24.6mm, 1, 4, 4.0mm, 250.0kHz, 6.6mm, 5.5mm, 2.5mm, 45.0A, 6) add(20.4mm, 2, 1, 4.0mm, 350.0kHz, 7.9mm, 4.6mm, 0.4mm, 45.0A, 6) add(26.0mm, 3, 1, 4.5mm, 350.0kHz, 6.7mm, 14.9mm, 1.3mm, 33.0A, 7) add(13.4mm, 4, 2, 4.0mm, 250.0kHz, 7.4mm, 6.5mm, 1.9mm, 36.0A, 6) add(12.0mm, 3, 3, 5.0mm, 150.0kHz, 5.8mm, 5.5mm, 1.9mm, 42.0A, 8) add(24.6mm, 1, 2, 4.5mm, 250.0kHz, 10.6mm, 12.5mm, 3.1mm, 45.0A, 7) add(26.7mm, 1, 1, 3.5mm, 150.0kHz, 14.0mm, 9.5mm, 3.1mm, 45.0A, 5) add(14.8mm, 3, 1, 4.5mm, 450.0kHz, 1.9mm, 6.1mm, 2.8mm, 39.0A, 7) add(7.8mm, 3, 1, 3.5mm, 250.0kHz, 4.2mm, 3.9mm, 3.4mm, 33.0A, 5) add(16.2mm, 4, 1, 3.5mm, 350.0kHz, 6.0mm, 9.2mm, 2.2mm, 42.0A, 5) add(26.0mm, 1, 1, 4.5mm, 250.0kHz, 5.9mm, 14.2mm, 3.1mm, 42.0A, 7) add(20.4mm, 3, 2, 4.5mm, 450.0kHz, 2.3mm, 10.9mm, 2.2mm, 36.0A, 7) add(23.2mm, 3, 3, 4.5mm, 350.0kHz, 12.1mm, 12.2mm, 3.4mm, 45.0A, 7) add(14.1mm, 1, 1, 4.5mm, 350.0kHz, 5.9mm, 4.6mm, 1.6mm, 30.0A, 7) add(26.0mm, 3, 1, 5.0mm, 350.0kHz, 13.9mm, 14.9mm, 1.3mm, 36.0A, 8) add(19.7mm, 1, 3, 4.0mm, 250.0kHz, 5.5mm, 10.7mm, 0.7mm, 39.0A, 6) add(25.3mm, 2, 4, 4.0mm, 350.0kHz, 13.9mm, 9.9mm, 2.5mm, 39.0A, 6) add(26.7mm, 2, 2, 3.5mm, 150.0kHz, 14.0mm, 10.2mm, 2.2mm, 42.0A, 5) add(18.3mm, 2, 4, 4.5mm, 150.0kHz, 3.0mm, 4.1mm, 3.1mm, 48.0A, 7) add(23.2mm, 1, 4, 3.5mm, 150.0kHz, 2.5mm, 9.4mm, 2.2mm, 45.0A, 5) add(16.2mm, 2, 2, 4.5mm, 250.0kHz, 9.2mm, 9.9mm, 2.5mm, 36.0A, 7) add(27.4mm, 4, 3, 4.5mm, 350.0kHz, 5.3mm, 13.2mm, 2.2mm, 39.0A, 7) add(23.9mm, 4, 4, 4.0mm, 250.0kHz, 14.6mm, 11.7mm, 2.5mm, 36.0A, 6) add(28.8mm, 3, 2, 4.0mm, 350.0kHz, 12.6mm, 7.2mm, 2.2mm, 45.0A, 6) add(21.8mm, 4, 2, 4.5mm, 450.0kHz, 7.2mm, 12.6mm, 3.4mm, 45.0A, 7) add(26.0mm, 2, 3, 4.5mm, 350.0kHz, 2.7mm, 8.6mm, 3.7mm, 42.0A, 7) add(26.7mm, 1, 1, 5.0mm, 350.0kHz, 2.8mm, 13.0mm, 3.4mm, 42.0A, 8) add(12.7mm, 2, 1, 3.5mm, 150.0kHz, 3.4mm, 5.7mm, 3.1mm, 36.0A, 5) add(18.3mm, 3, 4, 4.0mm, 150.0kHz, 4.6mm, 11.1mm, 2.8mm, 39.0A, 6) add(25.3mm, 4, 2, 4.5mm, 150.0kHz, 10.7mm, 9.9mm, 1.3mm, 30.0A, 7) add(14.8mm, 4, 1, 3.5mm, 250.0kHz, 5.9mm, 7.5mm, 1.6mm, 39.0A, 5) add(28.1mm, 1, 2, 3.5mm, 150.0kHz, 16.5mm, 16.8mm, 2.2mm, 48.0A, 5)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
  filtered_samples_2000_4: Parametric Sim._Setups=[Setup1]
    sweep dc1: 28.8mm
    sweep Nx: 2
    sweep Ny: 1
    sweep c: 4.5mm
    sweep f: 450.0kHz
    sweep dc2: 14.2mm
    sweep ht: 9.3mm
    sweep lg1: 3.7mm
    sweep i: 39.0A
    sweep mathindex: 7
    table edits: add(29.5mm, 3, 3, 4.5mm, 450.0kHz, 9.4mm, 13.6mm, 3.7mm, 48.0A, 7) add(27.4mm, 3, 3, 5.0mm, 450.0kHz, 10.1mm, 6.2mm, 3.7mm, 45.0A, 8) add(23.9mm, 3, 1, 4.0mm, 150.0kHz, 14.6mm, 6.1mm, 2.8mm, 30.0A, 6) add(5.0mm, 1, 4, 4.5mm, 250.0kHz, 2.6mm, 1.8mm, 2.2mm, 48.0A, 7) add(23.2mm, 1, 4, 4.0mm, 250.0kHz, 3.3mm, 13.6mm, 1.3mm, 42.0A, 6) add(19.0mm, 2, 1, 4.0mm, 450.0kHz, 7.8mm, 5.7mm, 2.8mm, 36.0A, 6) add(21.8mm, 2, 1, 4.0mm, 150.0kHz, 11.2mm, 13.3mm, 0.4mm, 33.0A, 6) add(22.5mm, 2, 1, 5.0mm, 450.0kHz, 9.7mm, 11.4mm, 3.7mm, 42.0A, 8) add(28.8mm, 4, 4, 4.5mm, 150.0kHz, 11.0mm, 17.0mm, 3.4mm, 45.0A, 7) add(15.5mm, 3, 3, 3.5mm, 350.0kHz, 6.0mm, 4.9mm, 3.4mm, 36.0A, 5) add(6.4mm, 2, 1, 4.0mm, 450.0kHz, 2.6mm, 3.5mm, 1.6mm, 33.0A, 6) add(29.5mm, 2, 4, 4.0mm, 250.0kHz, 13.4mm, 6.6mm, 2.8mm, 33.0A, 6) add(26.7mm, 3, 1, 4.0mm, 250.0kHz, 15.6mm, 6.7mm, 2.2mm, 39.0A, 6) add(29.5mm, 1, 1, 3.5mm, 250.0kHz, 11.8mm, 14.3mm, 1.9mm, 30.0A, 5) add(21.8mm, 2, 2, 4.0mm, 250.0kHz, 5.6mm, 11.2mm, 1.3mm, 36.0A, 6) add(9.2mm, 3, 1, 4.0mm, 250.0kHz, 5.8mm, 4.2mm, 1.0mm, 36.0A, 6) add(12.0mm, 3, 4, 4.0mm, 150.0kHz, 2.6mm, 6.9mm, 2.2mm, 39.0A, 6) add(29.5mm, 4, 3, 3.5mm, 350.0kHz, 15.0mm, 10.1mm, 2.2mm, 42.0A, 5) add(12.0mm, 1, 1, 5.0mm, 150.0kHz, 6.6mm, 5.5mm, 2.8mm, 39.0A, 8) add(28.1mm, 5, 3, 3.5mm, 150.0kHz, 10.1mm, 16.1mm, 2.8mm, 30.0A, 5) add(19.0mm, 2, 2, 4.0mm, 450.0kHz, 7.8mm, 6.4mm, 3.1mm, 33.0A, 6) add(15.5mm, 1, 2, 5.0mm, 350.0kHz, 6.0mm, 9.1mm, 1.9mm, 39.0A, 8) add(12.0mm, 1, 2, 4.5mm, 350.0kHz, 1.8mm, 3.4mm, 2.5mm, 33.0A, 7) add(24.6mm, 3, 1, 4.0mm, 350.0kHz, 14.6mm, 10.4mm, 1.9mm, 48.0A, 6) add(25.3mm, 4, 2, 4.0mm, 450.0kHz, 13.1mm, 5.7mm, 2.5mm, 45.0A, 6) add(28.1mm, 1, 2, 3.5mm, 350.0kHz, 3.7mm, 16.8mm, 2.8mm, 45.0A, 5) add(27.4mm, 1, 1, 4.0mm, 350.0kHz, 8.5mm, 10.4mm, 2.2mm, 36.0A, 6) add(16.2mm, 3, 1, 4.5mm, 150.0kHz, 7.6mm, 6.4mm, 2.8mm, 33.0A, 7) add(23.2mm, 4, 2, 4.0mm, 250.0kHz, 6.5mm, 5.2mm, 1.6mm, 36.0A, 6) add(23.9mm, 5, 2, 3.5mm, 150.0kHz, 4.2mm, 5.4mm, 2.2mm, 48.0A, 5) add(17.6mm, 2, 5, 3.5mm, 450.0kHz, 5.3mm, 6.1mm, 2.5mm, 45.0A, 5) add(17.6mm, 3, 2, 4.5mm, 150.0kHz, 6.1mm, 6.1mm, 2.8mm, 36.0A, 7) add(16.9mm, 2, 4, 4.5mm, 450.0kHz, 6.1mm, 3.8mm, 1.6mm, 39.0A, 7) add(22.5mm, 2, 2, 5.0mm, 150.0kHz, 7.3mm, 10.7mm, 1.9mm, 42.0A, 8) add(22.5mm, 1, 3, 3.5mm, 350.0kHz, 4.9mm, 7.2mm, 3.4mm, 30.0A, 5) add(22.5mm, 4, 3, 4.5mm, 250.0kHz, 12.9mm, 9.3mm, 3.1mm, 36.0A, 7) add(26.7mm, 1, 1, 4.5mm, 450.0kHz, 11.6mm, 14.4mm, 0.4mm, 42.0A, 7) add(28.8mm, 3, 1, 3.5mm, 450.0kHz, 2.2mm, 7.2mm, 1.3mm, 36.0A, 5) add(24.6mm, 4, 1, 3.5mm, 250.0kHz, 6.6mm, 9.7mm, 3.7mm, 33.0A, 5) add(22.5mm, 1, 3, 5.0mm, 350.0kHz, 12.1mm, 10.0mm, 1.0mm, 39.0A, 8) add(16.2mm, 3, 1, 3.5mm, 350.0kHz, 2.8mm, 7.8mm, 3.7mm, 39.0A, 5) add(26.0mm, 2, 1, 4.0mm, 450.0kHz, 4.3mm, 6.5mm, 2.8mm, 48.0A, 6) add(16.2mm, 2, 2, 3.5mm, 350.0kHz, 2.8mm, 5.7mm, 2.5mm, 42.0A, 5) add(23.2mm, 1, 2, 4.5mm, 150.0kHz, 8.9mm, 6.6mm, 3.7mm, 45.0A, 7) add(26.7mm, 4, 2, 4.0mm, 250.0kHz, 14.8mm, 6.7mm, 2.2mm, 36.0A, 6) add(23.9mm, 4, 2, 3.5mm, 250.0kHz, 9.8mm, 6.8mm, 3.4mm, 30.0A, 5) add(16.9mm, 3, 2, 4.5mm, 250.0kHz, 10.1mm, 3.8mm, 3.1mm, 33.0A, 7) add(23.9mm, 3, 1, 4.0mm, 350.0kHz, 4.2mm, 14.5mm, 0.4mm, 30.0A, 6) add(28.8mm, 1, 1, 3.5mm, 350.0kHz, 15.8mm, 10.7mm, 1.9mm, 39.0A, 5) add(11.3mm, 3, 3, 4.5mm, 150.0kHz, 5.8mm, 2.5mm, 2.5mm, 33.0A, 7) add(28.8mm, 3, 2, 3.5mm, 450.0kHz, 6.2mm, 7.9mm, 2.8mm, 33.0A, 5) add(27.4mm, 4, 2, 4.0mm, 250.0kHz, 11.7mm, 13.9mm, 3.1mm, 42.0A, 6) add(20.4mm, 1, 2, 4.0mm, 250.0kHz, 1.5mm, 11.6mm, 1.6mm, 48.0A, 6) add(20.4mm, 1, 1, 5.0mm, 350.0kHz, 7.1mm, 10.2mm, 2.5mm, 45.0A, 8) add(28.8mm, 4, 2, 4.5mm, 250.0kHz, 12.6mm, 12.8mm, 2.5mm, 33.0A, 7) add(14.1mm, 3, 2, 5.0mm, 450.0kHz, 4.3mm, 8.1mm, 1.6mm, 45.0A, 8) add(21.1mm, 1, 1, 3.5mm, 450.0kHz, 8.8mm, 4.7mm, 2.5mm, 48.0A, 5) add(14.1mm, 2, 2, 3.5mm, 150.0kHz, 6.7mm, 8.8mm, 3.4mm, 36.0A, 5) add(27.4mm, 3, 1, 4.5mm, 450.0kHz, 14.1mm, 11.1mm, 3.1mm, 39.0A, 7) add(11.3mm, 1, 3, 3.5mm, 350.0kHz, 6.6mm, 6.7mm, 2.2mm, 30.0A, 5)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
  filtered_samples_3000_1: Parametric Sim._Setups=[Setup1]
    sweep dc1: 24.6mm
    sweep Nx: 9
    sweep Ny: 9
    sweep c: 1.0mm
    sweep f: 350.0kHz
    sweep dc2: 5.0mm
    sweep ht: 10.4mm
    sweep lg1: 2.2mm
    sweep i: 4.0A
    sweep mathindex: 0
    table edits: add(23.9mm, 5, 10, 1.0mm, 250.0kHz, 2.6mm, 11.7mm, 1.6mm, 7.0A, 0) add(25.3mm, 5, 9, 1.0mm, 150.0kHz, 11.5mm, 10.6mm, 3.1mm, 7.0A, 0) add(21.8mm, 4, 4, 1.0mm, 450.0kHz, 4.0mm, 9.1mm, 2.2mm, 25.0A, 0) add(26.7mm, 7, 5, 1.5mm, 150.0kHz, 6.8mm, 8.1mm, 3.7mm, 13.0A, 1) add(8.5mm, 1, 2, 3.0mm, 250.0kHz, 2.6mm, 1.9mm, 2.8mm, 22.0A, 4) add(23.2mm, 6, 2, 2.5mm, 350.0kHz, 4.1mm, 5.9mm, 3.7mm, 19.0A, 3) add(25.3mm, 6, 3, 1.0mm, 450.0kHz, 8.3mm, 13.4mm, 3.1mm, 19.0A, 0) add(22.5mm, 10, 7, 1.0mm, 250.0kHz, 2.5mm, 10.7mm, 3.1mm, 1.0A, 0) add(28.8mm, 4, 10, 1.5mm, 150.0kHz, 6.2mm, 8.6mm, 3.7mm, 19.0A, 1) add(25.3mm, 3, 2, 3.0mm, 150.0kHz, 11.5mm, 14.8mm, 1.3mm, 28.0A, 4) add(17.6mm, 3, 3, 2.5mm, 350.0kHz, 2.1mm, 7.5mm, 1.3mm, 13.0A, 3) add(15.5mm, 1, 5, 3.0mm, 450.0kHz, 2.8mm, 3.5mm, 3.1mm, 19.0A, 4) add(16.9mm, 6, 4, 3.0mm, 150.0kHz, 4.5mm, 5.9mm, 2.2mm, 13.0A, 4) add(18.3mm, 10, 2, 1.0mm, 350.0kHz, 5.4mm, 5.5mm, 3.1mm, 13.0A, 0) add(21.1mm, 1, 3, 2.0mm, 150.0kHz, 8.0mm, 4.7mm, 0.1mm, 7.0A, 2) add(15.5mm, 7, 1, 1.5mm, 450.0kHz, 2.8mm, 6.3mm, 0.7mm, 1.0A, 1) add(25.3mm, 4, 9, 1.5mm, 150.0kHz, 12.3mm, 9.2mm, 1.9mm, 4.0A, 1) add(25.3mm, 8, 1, 1.0mm, 350.0kHz, 5.9mm, 7.8mm, 3.7mm, 13.0A, 0) add(14.1mm, 6, 1, 3.0mm, 150.0kHz, 1.1mm, 6.7mm, 3.4mm, 28.0A, 4) add(27.4mm, 9, 3, 1.5mm, 250.0kHz, 3.7mm, 13.9mm, 0.4mm, 1.0A, 1) add(24.6mm, 1, 1, 2.0mm, 350.0kHz, 10.6mm, 9.7mm, 1.6mm, 25.0A, 2) add(20.4mm, 6, 1, 3.0mm, 150.0kHz, 2.3mm, 5.3mm, 1.9mm, 13.0A, 4) add(19.0mm, 5, 4, 1.5mm, 450.0kHz, 8.6mm, 11.3mm, 3.4mm, 7.0A, 1) add(28.8mm, 7, 1, 1.5mm, 250.0kHz, 15.0mm, 7.2mm, 3.4mm, 19.0A, 1) add(26.0mm, 9, 2, 1.5mm, 150.0kHz, 13.9mm, 10.0mm, 3.4mm, 19.0A, 1) add(20.4mm, 9, 3, 1.5mm, 250.0kHz, 8.7mm, 11.6mm, 1.6mm, 1.0A, 1) add(25.3mm, 4, 1, 1.0mm, 450.0kHz, 7.5mm, 14.8mm, 0.4mm, 7.0A, 0) add(25.3mm, 8, 1, 1.5mm, 350.0kHz, 5.1mm, 14.1mm, 3.1mm, 1.0A, 1) add(26.7mm, 5, 8, 1.5mm, 450.0kHz, 3.6mm, 7.4mm, 2.2mm, 13.0A, 1) add(26.0mm, 2, 10, 1.5mm, 250.0kHz, 2.7mm, 6.5mm, 2.5mm, 1.0A, 1) add(25.3mm, 3, 6, 2.0mm, 450.0kHz, 15.5mm, 5.7mm, 0.7mm, 4.0A, 2) add(28.8mm, 4, 2, 1.0mm, 450.0kHz, 6.2mm, 12.8mm, 3.1mm, 10.0A, 0) add(26.0mm, 6, 4, 3.0mm, 450.0kHz, 13.9mm, 7.9mm, 3.7mm, 16.0A, 4) add(26.0mm, 6, 1, 1.0mm, 250.0kHz, 12.3mm, 11.4mm, 2.8mm, 19.0A, 0) add(29.5mm, 9, 7, 1.5mm, 350.0kHz, 15.0mm, 10.1mm, 1.0mm, 1.0A, 1) add(27.4mm, 5, 6, 3.0mm, 450.0kHz, 13.3mm, 6.9mm, 1.0mm, 7.0A, 4) add(16.2mm, 1, 7, 2.0mm, 450.0kHz, 1.2mm, 9.2mm, 0.7mm, 7.0A, 2) add(19.7mm, 4, 3, 1.0mm, 150.0kHz, 3.9mm, 6.5mm, 0.7mm, 10.0A, 0) add(28.8mm, 5, 3, 2.0mm, 250.0kHz, 15.0mm, 12.8mm, 3.7mm, 19.0A, 2) add(22.5mm, 8, 6, 1.5mm, 150.0kHz, 8.1mm, 7.9mm, 1.6mm, 4.0A, 1) add(28.8mm, 7, 1, 2.5mm, 250.0kHz, 16.6mm, 14.2mm, 0.7mm, 1.0A, 3) add(28.8mm, 4, 6, 1.0mm, 350.0kHz, 15.8mm, 15.6mm, 0.7mm, 4.0A, 0) add(28.1mm, 4, 10, 1.5mm, 150.0kHz, 14.1mm, 15.4mm, 2.2mm, 13.0A, 1) add(9.2mm, 5, 2, 3.0mm, 150.0kHz, 3.4mm, 2.8mm, 3.1mm, 10.0A, 4) add(24.6mm, 2, 10, 1.5mm, 450.0kHz, 6.6mm, 5.5mm, 3.7mm, 1.0A, 1) add(14.8mm, 1, 4, 2.0mm, 250.0kHz, 4.3mm, 3.3mm, 1.3mm, 16.0A, 2) add(9.9mm, 3, 6, 3.0mm, 350.0kHz, 4.2mm, 3.6mm, 1.6mm, 16.0A, 4) add(8.5mm, 5, 4, 3.0mm, 350.0kHz, 4.2mm, 2.6mm, 2.8mm, 16.0A, 4) add(29.5mm, 1, 9, 2.0mm, 450.0kHz, 15.0mm, 8.0mm, 0.7mm, 4.0A, 2) add(22.5mm, 1, 9, 1.0mm, 450.0kHz, 11.3mm, 6.5mm, 1.0mm, 13.0A, 0) add(6.4mm, 2, 2, 2.0mm, 350.0kHz, 1.8mm, 3.5mm, 0.7mm, 1.0A, 2) add(19.7mm, 1, 4, 2.5mm, 250.0kHz, 11.1mm, 5.8mm, 0.1mm, 1.0A, 3) add(28.8mm, 3, 5, 3.0mm, 350.0kHz, 14.2mm, 14.2mm, 1.0mm, 1.0A, 4) add(17.6mm, 2, 5, 1.0mm, 250.0kHz, 1.3mm, 6.1mm, 1.9mm, 22.0A, 0) add(14.8mm, 9, 3, 1.5mm, 250.0kHz, 2.7mm, 6.8mm, 1.3mm, 1.0A, 1) add(5.0mm, 9, 7, 1.5mm, 250.0kHz, 1.8mm, 1.8mm, 3.7mm, 4.0A, 1) add(12.0mm, 5, 3, 1.0mm, 350.0kHz, 5.8mm, 4.1mm, 3.4mm, 16.0A, 0) add(22.5mm, 5, 1, 1.5mm, 150.0kHz, 3.3mm, 7.2mm, 1.6mm, 4.0A, 1) add(16.2mm, 4, 5, 2.0mm, 150.0kHz, 5.2mm, 5.0mm, 2.8mm, 7.0A, 2) add(25.3mm, 3, 3, 2.0mm, 250.0kHz, 1.9mm, 9.9mm, 1.6mm, 28.0A, 2)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
  filtered_samples_3000_2: Parametric Sim._Setups=[Setup1]
    sweep dc1: 21.1mm
    sweep Nx: 2
    sweep Ny: 3
    sweep c: 1.5mm
    sweep f: 350.0kHz
    sweep dc2: 2.4mm
    sweep ht: 11.7mm
    sweep lg1: 2.8mm
    sweep i: 28.0A
    sweep mathindex: 1
    table edits: add(29.5mm, 1, 3, 2.0mm, 350.0kHz, 11.8mm, 7.3mm, 3.1mm, 4.0A, 2) add(21.1mm, 1, 1, 2.5mm, 250.0kHz, 5.6mm, 4.7mm, 3.4mm, 10.0A, 3) add(28.1mm, 1, 4, 2.0mm, 450.0kHz, 3.7mm, 10.5mm, 1.6mm, 16.0A, 2) add(27.4mm, 5, 1, 2.0mm, 250.0kHz, 15.7mm, 13.9mm, 0.4mm, 19.0A, 2) add(9.2mm, 4, 3, 2.0mm, 250.0kHz, 5.0mm, 4.9mm, 1.9mm, 13.0A, 2) add(29.5mm, 1, 1, 3.0mm, 150.0kHz, 12.6mm, 12.9mm, 3.1mm, 13.0A, 4) add(28.1mm, 7, 1, 2.5mm, 250.0kHz, 2.1mm, 15.4mm, 3.7mm, 19.0A, 3) add(12.0mm, 4, 2, 2.0mm, 250.0kHz, 5.8mm, 6.2mm, 2.8mm, 4.0A, 2) add(23.9mm, 6, 3, 3.0mm, 250.0kHz, 10.6mm, 10.3mm, 0.1mm, 1.0A, 4) add(26.0mm, 8, 2, 2.0mm, 350.0kHz, 5.1mm, 14.9mm, 1.9mm, 16.0A, 2) add(26.7mm, 1, 9, 2.0mm, 350.0kHz, 4.4mm, 9.5mm, 1.3mm, 28.0A, 2) add(21.1mm, 5, 1, 3.0mm, 150.0kHz, 4.8mm, 11.0mm, 1.6mm, 13.0A, 4) add(16.2mm, 3, 2, 2.5mm, 150.0kHz, 8.4mm, 4.3mm, 2.5mm, 1.0A, 3) add(28.8mm, 3, 2, 1.0mm, 450.0kHz, 12.6mm, 12.8mm, 2.8mm, 16.0A, 0) add(28.1mm, 5, 3, 2.0mm, 350.0kHz, 13.3mm, 10.5mm, 3.1mm, 1.0A, 2) add(29.5mm, 2, 7, 1.5mm, 250.0kHz, 6.2mm, 8.7mm, 3.4mm, 28.0A, 1) add(29.5mm, 4, 2, 1.0mm, 450.0kHz, 14.2mm, 13.6mm, 3.7mm, 10.0A, 0) add(12.0mm, 6, 8, 1.0mm, 250.0kHz, 5.0mm, 6.9mm, 3.4mm, 7.0A, 0) add(29.5mm, 6, 3, 1.5mm, 150.0kHz, 13.4mm, 14.3mm, 0.7mm, 4.0A, 1) add(24.6mm, 2, 8, 2.0mm, 150.0kHz, 14.6mm, 7.6mm, 3.7mm, 1.0A, 2) add(22.5mm, 1, 1, 1.0mm, 150.0kHz, 5.7mm, 7.9mm, 3.1mm, 4.0A, 0) add(17.6mm, 5, 7, 1.0mm, 350.0kHz, 7.7mm, 9.6mm, 3.1mm, 7.0A, 0) add(29.5mm, 7, 3, 1.0mm, 250.0kHz, 10.2mm, 15.0mm, 2.8mm, 13.0A, 0) add(20.4mm, 2, 7, 1.0mm, 250.0kHz, 4.7mm, 8.8mm, 1.6mm, 25.0A, 0) add(27.4mm, 7, 1, 1.0mm, 250.0kHz, 2.1mm, 6.2mm, 2.2mm, 22.0A, 0) add(28.8mm, 1, 6, 2.0mm, 350.0kHz, 14.2mm, 15.6mm, 1.3mm, 1.0A, 2) add(14.8mm, 1, 2, 3.0mm, 350.0kHz, 9.1mm, 3.3mm, 3.7mm, 25.0A, 4) add(19.0mm, 9, 3, 1.0mm, 350.0kHz, 11.0mm, 6.4mm, 1.0mm, 4.0A, 0) add(19.7mm, 1, 5, 2.5mm, 450.0kHz, 11.9mm, 7.9mm, 1.9mm, 16.0A, 3) add(29.5mm, 6, 8, 1.5mm, 450.0kHz, 17.4mm, 15.0mm, 3.7mm, 7.0A, 1) add(14.8mm, 7, 4, 1.0mm, 350.0kHz, 6.7mm, 8.9mm, 3.7mm, 28.0A, 0) add(23.2mm, 6, 1, 2.0mm, 450.0kHz, 8.1mm, 9.4mm, 2.8mm, 22.0A, 2) add(23.2mm, 9, 4, 1.0mm, 450.0kHz, 5.7mm, 11.5mm, 1.9mm, 10.0A, 0) add(26.7mm, 8, 3, 1.5mm, 150.0kHz, 10.0mm, 11.6mm, 3.7mm, 1.0A, 1) add(25.3mm, 5, 4, 2.0mm, 250.0kHz, 3.5mm, 10.6mm, 3.1mm, 28.0A, 2) add(28.1mm, 4, 3, 1.5mm, 350.0kHz, 8.5mm, 9.8mm, 1.0mm, 19.0A, 1) add(13.4mm, 5, 2, 3.0mm, 450.0kHz, 1.0mm, 7.2mm, 2.5mm, 7.0A, 4) add(28.1mm, 2, 1, 1.5mm, 450.0kHz, 4.5mm, 7.7mm, 1.9mm, 22.0A, 1) add(28.1mm, 4, 2, 3.0mm, 150.0kHz, 8.5mm, 6.3mm, 1.9mm, 25.0A, 4) add(12.0mm, 3, 4, 3.0mm, 450.0kHz, 1.0mm, 4.1mm, 2.2mm, 28.0A, 4) add(19.7mm, 3, 1, 2.5mm, 250.0kHz, 9.5mm, 7.9mm, 2.2mm, 13.0A, 3) add(26.0mm, 7, 4, 1.5mm, 150.0kHz, 13.1mm, 10.7mm, 2.5mm, 10.0A, 1) add(5.0mm, 7, 3, 2.5mm, 450.0kHz, 1.8mm, 1.1mm, 3.4mm, 4.0A, 3) add(27.4mm, 2, 7, 1.0mm, 450.0kHz, 7.7mm, 16.7mm, 3.4mm, 28.0A, 0) add(29.5mm, 1, 1, 3.0mm, 450.0kHz, 9.4mm, 7.3mm, 2.8mm, 13.0A, 4) add(11.3mm, 7, 3, 1.0mm, 450.0kHz, 4.2mm, 5.3mm, 3.1mm, 10.0A, 0) add(20.4mm, 8, 1, 1.5mm, 250.0kHz, 9.5mm, 11.6mm, 1.6mm, 19.0A, 1) add(25.3mm, 6, 4, 3.0mm, 450.0kHz, 9.9mm, 11.3mm, 3.1mm, 1.0A, 4) add(20.4mm, 8, 5, 2.0mm, 350.0kHz, 11.1mm, 6.0mm, 2.8mm, 1.0A, 2) add(28.1mm, 3, 1, 2.0mm, 450.0kHz, 8.5mm, 16.8mm, 1.3mm, 1.0A, 2) add(28.1mm, 2, 5, 1.0mm, 350.0kHz, 15.7mm, 6.3mm, 3.1mm, 4.0A, 0) add(28.1mm, 4, 7, 1.0mm, 450.0kHz, 2.1mm, 13.3mm, 3.1mm, 22.0A, 0) add(14.1mm, 2, 7, 2.0mm, 450.0kHz, 6.7mm, 6.0mm, 2.5mm, 16.0A, 2) add(28.1mm, 2, 9, 1.5mm, 250.0kHz, 10.9mm, 11.2mm, 1.9mm, 19.0A, 1) add(24.6mm, 5, 4, 1.5mm, 350.0kHz, 9.0mm, 13.2mm, 3.1mm, 28.0A, 1) add(24.6mm, 2, 8, 2.0mm, 450.0kHz, 7.4mm, 11.1mm, 2.5mm, 28.0A, 2) add(14.8mm, 4, 2, 2.5mm, 150.0kHz, 3.5mm, 8.2mm, 3.7mm, 13.0A, 3) add(27.4mm, 7, 3, 2.0mm, 150.0kHz, 7.7mm, 10.4mm, 2.2mm, 13.0A, 2) add(27.4mm, 3, 4, 2.5mm, 250.0kHz, 10.1mm, 11.1mm, 3.4mm, 4.0A, 3) add(23.2mm, 6, 1, 3.0mm, 350.0kHz, 1.7mm, 13.6mm, 1.3mm, 16.0A, 4)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
  filtered_samples_3000_3: Parametric Sim._Setups=[Setup1]
    sweep dc1: 28.8mm
    sweep Nx: 6
    sweep Ny: 6
    sweep c: 2.5mm
    sweep f: 250.0kHz
    sweep dc2: 12.6mm
    sweep ht: 17.0mm
    sweep lg1: 1.9mm
    sweep i: 1.0A
    sweep mathindex: 3
    table edits: add(26.0mm, 9, 5, 1.5mm, 350.0kHz, 5.9mm, 5.8mm, 3.4mm, 10.0A, 1) add(23.9mm, 4, 4, 1.0mm, 150.0kHz, 12.2mm, 14.5mm, 0.7mm, 1.0A, 0) add(29.5mm, 6, 6, 2.0mm, 450.0kHz, 4.6mm, 8.7mm, 3.7mm, 10.0A, 2) add(19.0mm, 4, 3, 2.0mm, 350.0kHz, 3.0mm, 9.9mm, 3.1mm, 16.0A, 2) add(16.2mm, 4, 4, 2.5mm, 150.0kHz, 8.4mm, 5.7mm, 2.2mm, 22.0A, 3) add(23.9mm, 3, 3, 3.0mm, 250.0kHz, 14.6mm, 8.9mm, 1.9mm, 22.0A, 4) add(23.9mm, 2, 6, 1.0mm, 350.0kHz, 9.0mm, 13.1mm, 2.2mm, 28.0A, 0) add(17.6mm, 4, 2, 1.5mm, 450.0kHz, 8.5mm, 4.0mm, 1.6mm, 22.0A, 1) add(13.4mm, 1, 7, 1.0mm, 350.0kHz, 5.8mm, 7.2mm, 0.4mm, 4.0A, 0) add(26.0mm, 8, 1, 1.5mm, 350.0kHz, 15.5mm, 5.8mm, 3.7mm, 10.0A, 1) add(19.0mm, 5, 5, 3.0mm, 350.0kHz, 11.0mm, 9.2mm, 2.8mm, 13.0A, 4) add(25.3mm, 4, 1, 2.5mm, 150.0kHz, 8.3mm, 7.8mm, 2.2mm, 16.0A, 3) add(28.1mm, 7, 4, 2.5mm, 350.0kHz, 14.9mm, 14.7mm, 3.4mm, 10.0A, 3) add(14.8mm, 9, 6, 1.0mm, 250.0kHz, 6.7mm, 7.5mm, 2.2mm, 1.0A, 0) add(9.9mm, 3, 6, 2.5mm, 350.0kHz, 3.4mm, 4.3mm, 2.8mm, 4.0A, 3) add(9.2mm, 2, 8, 2.0mm, 250.0kHz, 4.2mm, 4.2mm, 1.6mm, 4.0A, 2) add(29.5mm, 1, 10, 1.5mm, 450.0kHz, 6.2mm, 15.7mm, 2.8mm, 16.0A, 1) add(5.0mm, 3, 8, 1.0mm, 250.0kHz, 1.0mm, 1.8mm, 2.8mm, 4.0A, 0) add(22.5mm, 4, 9, 2.0mm, 450.0kHz, 12.9mm, 5.8mm, 1.3mm, 1.0A, 2) add(28.8mm, 6, 5, 3.0mm, 350.0kHz, 5.4mm, 15.6mm, 3.7mm, 10.0A, 4) add(28.1mm, 2, 6, 1.5mm, 350.0kHz, 2.1mm, 16.8mm, 3.4mm, 25.0A, 1) add(26.7mm, 7, 3, 1.0mm, 450.0kHz, 3.6mm, 6.0mm, 2.2mm, 22.0A, 0) add(28.1mm, 4, 6, 3.0mm, 350.0kHz, 11.7mm, 11.2mm, 3.4mm, 25.0A, 4) add(27.4mm, 3, 1, 1.5mm, 450.0kHz, 3.7mm, 11.1mm, 1.3mm, 22.0A, 1) add(26.7mm, 1, 6, 2.5mm, 350.0kHz, 6.8mm, 15.8mm, 0.7mm, 10.0A, 3) add(26.7mm, 5, 3, 1.0mm, 250.0kHz, 11.6mm, 7.4mm, 3.7mm, 7.0A, 0) add(25.3mm, 2, 3, 1.0mm, 450.0kHz, 1.9mm, 12.7mm, 1.9mm, 13.0A, 0) add(14.8mm, 9, 2, 1.5mm, 350.0kHz, 5.1mm, 6.8mm, 0.7mm, 4.0A, 1) add(20.4mm, 8, 1, 1.5mm, 450.0kHz, 1.5mm, 8.8mm, 2.8mm, 1.0A, 1) add(28.8mm, 2, 2, 1.5mm, 150.0kHz, 7.0mm, 17.0mm, 0.7mm, 13.0A, 1) add(21.8mm, 2, 6, 2.0mm, 450.0kHz, 9.6mm, 6.3mm, 1.9mm, 13.0A, 2) add(28.8mm, 10, 1, 1.5mm, 350.0kHz, 5.4mm, 7.2mm, 2.5mm, 10.0A, 1) add(28.8mm, 6, 1, 2.5mm, 250.0kHz, 9.4mm, 15.6mm, 2.2mm, 7.0A, 3) add(29.5mm, 5, 2, 2.5mm, 350.0kHz, 14.2mm, 15.0mm, 2.5mm, 19.0A, 3) add(12.7mm, 4, 6, 1.5mm, 450.0kHz, 2.6mm, 6.4mm, 3.4mm, 4.0A, 1) add(28.8mm, 10, 1, 1.5mm, 150.0kHz, 12.6mm, 7.9mm, 3.7mm, 7.0A, 1) add(29.5mm, 2, 2, 1.0mm, 350.0kHz, 11.8mm, 17.1mm, 0.7mm, 16.0A, 0) add(28.1mm, 3, 1, 2.0mm, 450.0kHz, 5.3mm, 14.7mm, 2.8mm, 1.0A, 2) add(27.4mm, 4, 9, 1.0mm, 350.0kHz, 14.9mm, 14.6mm, 2.8mm, 4.0A, 0) add(19.7mm, 1, 6, 1.0mm, 150.0kHz, 10.3mm, 7.9mm, 3.4mm, 16.0A, 0) add(16.2mm, 8, 5, 1.0mm, 350.0kHz, 5.2mm, 6.4mm, 3.4mm, 13.0A, 0) add(17.6mm, 6, 1, 2.5mm, 350.0kHz, 8.5mm, 10.3mm, 2.8mm, 19.0A, 3) add(25.3mm, 4, 10, 1.5mm, 450.0kHz, 4.3mm, 15.5mm, 1.6mm, 4.0A, 1) add(28.1mm, 5, 6, 1.5mm, 250.0kHz, 2.9mm, 10.5mm, 3.7mm, 4.0A, 1) add(24.6mm, 2, 4, 2.5mm, 250.0kHz, 12.2mm, 13.9mm, 1.0mm, 13.0A, 3) add(27.4mm, 6, 2, 3.0mm, 150.0kHz, 6.9mm, 13.2mm, 1.9mm, 10.0A, 4) add(28.1mm, 10, 1, 1.0mm, 150.0kHz, 2.1mm, 6.3mm, 3.7mm, 10.0A, 0) add(26.7mm, 4, 1, 3.0mm, 350.0kHz, 2.0mm, 9.5mm, 1.6mm, 1.0A, 4) add(5.0mm, 2, 2, 3.0mm, 450.0kHz, 1.8mm, 1.1mm, 1.3mm, 7.0A, 4) add(24.6mm, 6, 3, 1.0mm, 350.0kHz, 2.6mm, 6.9mm, 2.8mm, 13.0A, 0) add(14.8mm, 6, 5, 3.0mm, 150.0kHz, 4.3mm, 4.7mm, 3.1mm, 1.0A, 4) add(28.8mm, 1, 5, 2.5mm, 350.0kHz, 7.0mm, 17.0mm, 2.5mm, 13.0A, 3) add(23.9mm, 1, 2, 2.0mm, 450.0kHz, 9.8mm, 6.1mm, 1.0mm, 7.0A, 2) add(14.8mm, 7, 3, 1.0mm, 250.0kHz, 4.3mm, 3.3mm, 2.5mm, 13.0A, 0) add(14.8mm, 7, 8, 1.0mm, 250.0kHz, 5.9mm, 6.1mm, 3.7mm, 13.0A, 0) add(13.4mm, 5, 1, 1.5mm, 450.0kHz, 8.2mm, 3.0mm, 1.6mm, 16.0A, 1) add(24.6mm, 9, 4, 1.5mm, 450.0kHz, 3.4mm, 14.6mm, 1.0mm, 1.0A, 1) add(28.8mm, 1, 9, 2.0mm, 150.0kHz, 3.0mm, 10.7mm, 3.4mm, 10.0A, 2) add(27.4mm, 3, 3, 2.5mm, 450.0kHz, 12.5mm, 9.0mm, 3.4mm, 1.0A, 3) add(28.1mm, 4, 1, 1.5mm, 250.0kHz, 13.3mm, 9.1mm, 0.4mm, 22.0A, 1)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
  filtered_samples_3000_4: Parametric Sim._Setups=[Setup1]
    sweep dc1: 21.1mm
    sweep Nx: 5
    sweep Ny: 6
    sweep c: 1.5mm
    sweep f: 250.0kHz
    sweep dc2: 1.6mm
    sweep ht: 12.4mm
    sweep lg1: 3.4mm
    sweep i: 7.0A
    sweep mathindex: 1
    table edits: add(8.5mm, 1, 1, 3.0mm, 450.0kHz, 3.4mm, 1.9mm, 0.1mm, 7.0A, 4) add(23.9mm, 1, 5, 2.0mm, 350.0kHz, 12.2mm, 6.8mm, 3.1mm, 10.0A, 2) add(26.7mm, 1, 7, 2.0mm, 450.0kHz, 2.8mm, 9.5mm, 3.4mm, 1.0A, 2) add(14.8mm, 10, 8, 1.0mm, 250.0kHz, 1.9mm, 4.7mm, 2.5mm, 4.0A, 0) add(22.5mm, 7, 3, 2.0mm, 350.0kHz, 6.5mm, 5.1mm, 2.2mm, 25.0A, 2) add(11.3mm, 4, 4, 3.0mm, 350.0kHz, 1.0mm, 4.6mm, 2.2mm, 10.0A, 4) add(25.3mm, 7, 2, 1.5mm, 150.0kHz, 14.7mm, 14.8mm, 2.5mm, 19.0A, 1) add(20.4mm, 2, 2, 1.5mm, 450.0kHz, 3.9mm, 5.3mm, 2.2mm, 10.0A, 1) add(26.7mm, 9, 6, 1.5mm, 350.0kHz, 7.6mm, 6.0mm, 3.4mm, 7.0A, 1) add(18.3mm, 5, 5, 1.5mm, 450.0kHz, 10.2mm, 6.2mm, 2.8mm, 19.0A, 1) add(28.1mm, 2, 6, 2.5mm, 150.0kHz, 10.1mm, 15.4mm, 2.8mm, 7.0A, 3) add(7.1mm, 1, 6, 2.0mm, 350.0kHz, 3.4mm, 2.3mm, 1.6mm, 13.0A, 2) add(27.4mm, 4, 3, 2.0mm, 250.0kHz, 12.5mm, 13.2mm, 2.2mm, 1.0A, 2) add(22.5mm, 2, 3, 2.5mm, 450.0kHz, 7.3mm, 8.6mm, 2.2mm, 1.0A, 3) add(23.9mm, 2, 8, 1.0mm, 450.0kHz, 10.6mm, 10.3mm, 2.2mm, 10.0A, 0) add(26.0mm, 3, 4, 1.0mm, 150.0kHz, 3.5mm, 7.9mm, 2.5mm, 4.0A, 0) add(27.4mm, 6, 1, 2.5mm, 350.0kHz, 15.7mm, 6.9mm, 0.4mm, 13.0A, 3) add(25.3mm, 5, 2, 1.5mm, 150.0kHz, 13.1mm, 8.5mm, 1.3mm, 16.0A, 1) add(29.5mm, 10, 2, 1.0mm, 150.0kHz, 9.4mm, 13.6mm, 2.8mm, 28.0A, 0) add(19.7mm, 1, 1, 3.0mm, 350.0kHz, 4.7mm, 7.9mm, 2.2mm, 19.0A, 4) add(26.7mm, 5, 1, 1.5mm, 250.0kHz, 8.4mm, 12.3mm, 3.1mm, 7.0A, 1) add(17.6mm, 1, 3, 1.0mm, 350.0kHz, 3.7mm, 7.5mm, 3.7mm, 13.0A, 0) add(12.7mm, 1, 6, 1.5mm, 250.0kHz, 3.4mm, 4.3mm, 1.0mm, 28.0A, 1) add(16.2mm, 1, 1, 2.0mm, 450.0kHz, 7.6mm, 7.1mm, 2.2mm, 13.0A, 2) add(15.5mm, 4, 3, 3.0mm, 350.0kHz, 8.4mm, 5.6mm, 3.1mm, 4.0A, 4) add(27.4mm, 1, 7, 2.5mm, 450.0kHz, 6.1mm, 10.4mm, 1.9mm, 16.0A, 3) add(22.5mm, 4, 2, 2.5mm, 150.0kHz, 8.1mm, 10.0mm, 0.1mm, 1.0A, 3) add(26.7mm, 5, 4, 1.0mm, 450.0kHz, 6.8mm, 15.8mm, 0.4mm, 4.0A, 0) add(24.6mm, 3, 1, 2.0mm, 250.0kHz, 1.8mm, 11.1mm, 3.7mm, 10.0A, 2) add(24.6mm, 3, 1, 1.0mm, 350.0kHz, 9.0mm, 11.1mm, 1.6mm, 19.0A, 0) add(14.8mm, 9, 3, 2.0mm, 350.0kHz, 4.3mm, 8.2mm, 2.5mm, 22.0A, 2) add(16.2mm, 5, 2, 1.0mm, 250.0kHz, 4.4mm, 5.7mm, 1.3mm, 25.0A, 0) add(27.4mm, 2, 8, 2.0mm, 150.0kHz, 2.9mm, 13.2mm, 1.9mm, 25.0A, 2) add(27.4mm, 2, 6, 1.0mm, 250.0kHz, 6.9mm, 11.1mm, 2.2mm, 22.0A, 0) add(14.1mm, 6, 5, 2.0mm, 250.0kHz, 7.5mm, 6.7mm, 2.8mm, 7.0A, 2) add(9.9mm, 7, 2, 1.5mm, 150.0kHz, 1.0mm, 3.6mm, 1.0mm, 13.0A, 1) add(28.1mm, 5, 3, 1.0mm, 450.0kHz, 10.1mm, 7.0mm, 2.2mm, 13.0A, 0) add(26.7mm, 1, 2, 3.0mm, 350.0kHz, 6.0mm, 13.7mm, 2.2mm, 10.0A, 4) add(24.6mm, 6, 1, 1.5mm, 150.0kHz, 13.8mm, 12.5mm, 0.7mm, 25.0A, 1) add(13.4mm, 1, 3, 2.5mm, 250.0kHz, 3.4mm, 7.9mm, 2.2mm, 25.0A, 3) add(19.7mm, 3, 8, 1.0mm, 150.0kHz, 2.3mm, 6.5mm, 3.7mm, 4.0A, 0) add(25.3mm, 7, 4, 2.0mm, 150.0kHz, 11.5mm, 14.1mm, 2.8mm, 16.0A, 2) add(9.2mm, 5, 1, 1.5mm, 250.0kHz, 5.8mm, 5.6mm, 1.3mm, 19.0A, 1) add(20.4mm, 7, 1, 1.0mm, 450.0kHz, 7.1mm, 7.4mm, 3.7mm, 25.0A, 0) add(7.1mm, 1, 9, 1.0mm, 250.0kHz, 1.0mm, 2.3mm, 3.7mm, 16.0A, 0) add(27.4mm, 2, 1, 2.0mm, 450.0kHz, 6.1mm, 9.0mm, 1.9mm, 22.0A, 2) add(28.1mm, 2, 6, 1.5mm, 450.0kHz, 10.1mm, 16.8mm, 0.4mm, 4.0A, 1) add(14.8mm, 4, 1, 1.5mm, 350.0kHz, 5.9mm, 5.4mm, 3.1mm, 1.0A, 1) add(23.9mm, 6, 2, 2.0mm, 150.0kHz, 7.4mm, 13.1mm, 1.6mm, 4.0A, 2) add(21.1mm, 4, 2, 2.5mm, 250.0kHz, 3.2mm, 11.0mm, 3.4mm, 4.0A, 3) add(29.5mm, 5, 8, 2.0mm, 250.0kHz, 13.4mm, 12.2mm, 2.8mm, 7.0A, 2) add(19.0mm, 6, 9, 1.5mm, 150.0kHz, 6.2mm, 10.6mm, 2.8mm, 7.0A, 1) add(18.3mm, 8, 8, 1.5mm, 250.0kHz, 2.2mm, 6.9mm, 3.4mm, 4.0A, 1) add(26.0mm, 8, 8, 2.0mm, 450.0kHz, 14.7mm, 7.2mm, 3.1mm, 1.0A, 2) add(11.3mm, 7, 1, 1.0mm, 350.0kHz, 3.4mm, 3.9mm, 3.1mm, 7.0A, 0) add(28.1mm, 3, 1, 3.0mm, 450.0kHz, 11.7mm, 12.6mm, 2.5mm, 25.0A, 4) add(14.1mm, 5, 1, 1.0mm, 250.0kHz, 5.9mm, 6.7mm, 1.0mm, 19.0A, 0) add(29.5mm, 1, 3, 1.0mm, 150.0kHz, 10.2mm, 12.2mm, 0.4mm, 7.0A, 0) add(14.1mm, 5, 1, 3.0mm, 150.0kHz, 1.9mm, 8.8mm, 3.7mm, 7.0A, 4) add(27.4mm, 4, 9, 1.5mm, 150.0kHz, 15.7mm, 9.7mm, 3.1mm, 4.0A, 1)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
  filtered_samples_3000_5: Parametric Sim._Setups=[Setup1]
    sweep dc1: 24.6mm
    sweep Nx: 6
    sweep Ny: 3
    sweep c: 3.0mm
    sweep f: 450.0kHz
    sweep dc2: 9.8mm
    sweep ht: 7.6mm
    sweep lg1: 0.7mm
    sweep i: 7.0A
    sweep mathindex: 4
    table edits: add(23.9mm, 1, 4, 1.5mm, 450.0kHz, 13.0mm, 12.4mm, 3.4mm, 28.0A, 1) add(9.2mm, 1, 4, 2.5mm, 150.0kHz, 2.6mm, 4.9mm, 2.5mm, 22.0A, 3) add(26.0mm, 8, 1, 1.0mm, 450.0kHz, 13.1mm, 14.2mm, 3.1mm, 16.0A, 0) add(27.4mm, 9, 7, 1.5mm, 150.0kHz, 9.3mm, 6.2mm, 1.3mm, 4.0A, 1) add(26.0mm, 4, 6, 2.5mm, 350.0kHz, 14.7mm, 15.6mm, 3.1mm, 4.0A, 3) add(26.0mm, 5, 1, 2.0mm, 450.0kHz, 10.7mm, 11.4mm, 1.0mm, 19.0A, 2) add(21.1mm, 6, 3, 2.5mm, 250.0kHz, 4.8mm, 4.7mm, 1.3mm, 1.0A, 3) add(20.4mm, 2, 10, 1.5mm, 450.0kHz, 6.3mm, 7.4mm, 1.9mm, 7.0A, 1) add(20.4mm, 3, 5, 1.0mm, 450.0kHz, 10.3mm, 8.1mm, 3.4mm, 22.0A, 0) add(28.1mm, 2, 4, 3.0mm, 450.0kHz, 15.7mm, 11.2mm, 3.4mm, 13.0A, 4) add(19.7mm, 3, 2, 2.0mm, 350.0kHz, 7.9mm, 4.4mm, 3.7mm, 1.0A, 2) add(14.8mm, 6, 8, 2.0mm, 450.0kHz, 5.9mm, 6.1mm, 2.5mm, 1.0A, 2) add(22.5mm, 3, 4, 2.0mm, 450.0kHz, 12.9mm, 7.9mm, 1.0mm, 1.0A, 2) add(28.1mm, 1, 4, 1.5mm, 250.0kHz, 16.5mm, 16.1mm, 3.4mm, 28.0A, 1) add(26.0mm, 5, 2, 1.0mm, 250.0kHz, 9.1mm, 7.9mm, 2.8mm, 10.0A, 0) add(27.4mm, 2, 1, 1.5mm, 350.0kHz, 16.5mm, 16.0mm, 1.0mm, 13.0A, 1) add(28.8mm, 2, 7, 1.0mm, 150.0kHz, 6.2mm, 9.3mm, 3.1mm, 19.0A, 0) add(29.5mm, 4, 3, 3.0mm, 350.0kHz, 9.4mm, 17.1mm, 2.2mm, 28.0A, 4) add(17.6mm, 4, 1, 2.5mm, 250.0kHz, 9.3mm, 6.8mm, 3.7mm, 10.0A, 3) add(19.0mm, 2, 2, 1.5mm, 350.0kHz, 1.4mm, 6.4mm, 2.5mm, 7.0A, 1) add(25.3mm, 8, 3, 2.0mm, 450.0kHz, 9.1mm, 13.4mm, 2.5mm, 10.0A, 2) add(19.7mm, 8, 4, 1.0mm, 350.0kHz, 6.3mm, 12.1mm, 1.0mm, 4.0A, 0) add(26.7mm, 1, 2, 3.0mm, 250.0kHz, 14.0mm, 10.9mm, 1.3mm, 22.0A, 4) add(29.5mm, 2, 6, 1.5mm, 350.0kHz, 15.0mm, 10.1mm, 3.4mm, 13.0A, 1) add(21.1mm, 6, 3, 2.5mm, 250.0kHz, 7.2mm, 6.8mm, 2.8mm, 16.0A, 3) add(19.7mm, 3, 1, 3.0mm, 250.0kHz, 3.1mm, 7.9mm, 2.5mm, 4.0A, 4) add(28.8mm, 4, 2, 2.0mm, 250.0kHz, 2.2mm, 6.5mm, 3.4mm, 7.0A, 2) add(29.5mm, 2, 6, 2.0mm, 150.0kHz, 16.6mm, 9.4mm, 1.0mm, 16.0A, 2) add(5.7mm, 4, 7, 1.0mm, 450.0kHz, 1.0mm, 3.4mm, 1.0mm, 7.0A, 0) add(26.7mm, 6, 4, 2.5mm, 350.0kHz, 15.6mm, 13.0mm, 3.4mm, 4.0A, 3) add(21.1mm, 2, 2, 1.0mm, 450.0kHz, 10.4mm, 6.1mm, 1.9mm, 19.0A, 0) add(28.1mm, 6, 7, 2.5mm, 250.0kHz, 2.1mm, 11.9mm, 3.7mm, 19.0A, 3) add(17.6mm, 7, 4, 1.5mm, 450.0kHz, 1.3mm, 10.3mm, 3.1mm, 10.0A, 1) add(24.6mm, 3, 5, 2.5mm, 450.0kHz, 9.8mm, 12.5mm, 0.7mm, 10.0A, 3) add(21.8mm, 1, 4, 1.0mm, 250.0kHz, 9.6mm, 13.3mm, 3.4mm, 10.0A, 0) add(27.4mm, 3, 4, 1.5mm, 450.0kHz, 3.7mm, 11.1mm, 0.7mm, 4.0A, 1) add(26.0mm, 1, 1, 1.5mm, 350.0kHz, 5.9mm, 10.0mm, 2.2mm, 25.0A, 1) add(28.1mm, 2, 8, 1.5mm, 150.0kHz, 7.7mm, 6.3mm, 3.7mm, 19.0A, 1) add(19.0mm, 1, 8, 1.5mm, 250.0kHz, 10.2mm, 6.4mm, 0.7mm, 19.0A, 1) add(28.8mm, 10, 5, 1.5mm, 350.0kHz, 11.8mm, 17.0mm, 2.8mm, 7.0A, 1) add(21.8mm, 3, 6, 2.5mm, 350.0kHz, 9.6mm, 6.3mm, 3.1mm, 22.0A, 3) add(25.3mm, 6, 5, 3.0mm, 350.0kHz, 9.9mm, 13.4mm, 2.5mm, 1.0A, 4) add(28.1mm, 1, 3, 3.0mm, 250.0kHz, 7.7mm, 7.7mm, 3.4mm, 28.0A, 4) add(20.4mm, 6, 2, 3.0mm, 250.0kHz, 6.3mm, 8.8mm, 1.0mm, 16.0A, 4) add(21.1mm, 6, 2, 1.5mm, 250.0kHz, 6.4mm, 10.3mm, 2.8mm, 16.0A, 1) add(11.3mm, 4, 1, 2.5mm, 450.0kHz, 3.4mm, 3.2mm, 1.9mm, 1.0A, 3) add(23.2mm, 4, 3, 1.5mm, 350.0kHz, 12.1mm, 6.6mm, 2.8mm, 25.0A, 1) add(26.0mm, 7, 3, 1.0mm, 450.0kHz, 14.7mm, 8.6mm, 3.1mm, 22.0A, 0) add(29.5mm, 8, 9, 1.5mm, 150.0kHz, 17.4mm, 8.7mm, 3.4mm, 7.0A, 1) add(23.9mm, 9, 9, 1.0mm, 150.0kHz, 5.0mm, 10.3mm, 1.9mm, 1.0A, 0) add(13.4mm, 3, 6, 1.0mm, 250.0kHz, 1.0mm, 7.9mm, 2.5mm, 25.0A, 0) add(28.8mm, 7, 3, 1.0mm, 250.0kHz, 8.6mm, 13.5mm, 1.6mm, 10.0A, 0) add(28.1mm, 1, 8, 2.0mm, 350.0kHz, 16.5mm, 6.3mm, 3.7mm, 4.0A, 2) add(26.7mm, 5, 3, 3.0mm, 250.0kHz, 5.2mm, 15.1mm, 0.1mm, 1.0A, 4) add(12.7mm, 4, 9, 1.5mm, 250.0kHz, 7.4mm, 4.3mm, 1.6mm, 7.0A, 1) add(9.9mm, 6, 4, 2.0mm, 150.0kHz, 5.8mm, 2.9mm, 3.4mm, 25.0A, 2) add(12.7mm, 3, 3, 2.5mm, 150.0kHz, 6.6mm, 2.9mm, 1.6mm, 22.0A, 3) add(28.8mm, 1, 2, 3.0mm, 350.0kHz, 3.8mm, 10.7mm, 3.7mm, 10.0A, 4) add(15.5mm, 3, 9, 1.0mm, 350.0kHz, 4.4mm, 9.1mm, 1.9mm, 13.0A, 0) add(16.2mm, 3, 9, 2.0mm, 250.0kHz, 2.8mm, 7.1mm, 2.5mm, 13.0A, 2)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
  filtered_samples_3000_6: Parametric Sim._Setups=[Setup1]
    sweep dc1: 29.5mm
    sweep Nx: 9
    sweep Ny: 2
    sweep c: 2.0mm
    sweep f: 150.0kHz
    sweep dc2: 5.4mm
    sweep ht: 17.8mm
    sweep lg1: 2.2mm
    sweep i: 13.0A
    sweep mathindex: 2
    table edits: add(21.1mm, 5, 2, 1.5mm, 450.0kHz, 6.4mm, 9.6mm, 1.9mm, 7.0A, 1) add(21.8mm, 8, 10, 1.5mm, 450.0kHz, 1.6mm, 8.4mm, 2.8mm, 7.0A, 1) add(17.6mm, 4, 3, 1.5mm, 250.0kHz, 10.1mm, 9.6mm, 1.0mm, 4.0A, 1) add(29.5mm, 9, 4, 2.0mm, 250.0kHz, 14.2mm, 16.4mm, 2.8mm, 16.0A, 2) add(9.2mm, 2, 8, 1.0mm, 150.0kHz, 2.6mm, 4.9mm, 0.7mm, 4.0A, 0) add(23.9mm, 9, 1, 1.0mm, 150.0kHz, 7.4mm, 11.0mm, 3.4mm, 4.0A, 0) add(16.2mm, 3, 3, 1.0mm, 450.0kHz, 4.4mm, 4.3mm, 3.1mm, 16.0A, 0) add(15.5mm, 10, 3, 1.0mm, 350.0kHz, 2.8mm, 7.7mm, 2.5mm, 13.0A, 0) add(13.4mm, 3, 4, 2.0mm, 450.0kHz, 1.8mm, 7.9mm, 3.4mm, 16.0A, 2) add(24.6mm, 2, 9, 2.0mm, 450.0kHz, 13.8mm, 7.6mm, 3.4mm, 7.0A, 2) add(29.5mm, 3, 2, 2.5mm, 250.0kHz, 12.6mm, 8.7mm, 2.8mm, 1.0A, 3) add(23.2mm, 8, 4, 1.5mm, 250.0kHz, 5.7mm, 10.1mm, 1.6mm, 1.0A, 1) add(28.1mm, 9, 7, 1.5mm, 450.0kHz, 7.7mm, 15.4mm, 0.7mm, 1.0A, 1) add(17.6mm, 1, 7, 2.5mm, 450.0kHz, 2.9mm, 8.2mm, 2.2mm, 19.0A, 3) add(24.6mm, 4, 10, 1.0mm, 150.0kHz, 10.6mm, 6.9mm, 1.6mm, 4.0A, 0) add(24.6mm, 8, 1, 1.5mm, 150.0kHz, 11.4mm, 7.6mm, 2.8mm, 7.0A, 1) add(23.2mm, 9, 6, 1.0mm, 350.0kHz, 4.9mm, 7.3mm, 1.9mm, 1.0A, 0) add(23.9mm, 1, 3, 1.5mm, 350.0kHz, 3.4mm, 5.4mm, 1.9mm, 19.0A, 1) add(28.8mm, 2, 2, 3.0mm, 450.0kHz, 15.0mm, 7.9mm, 2.8mm, 25.0A, 4) add(14.1mm, 4, 3, 1.0mm, 150.0kHz, 8.3mm, 3.9mm, 2.8mm, 13.0A, 0) add(19.0mm, 9, 1, 1.0mm, 150.0kHz, 4.6mm, 10.6mm, 3.7mm, 16.0A, 0) add(13.4mm, 9, 2, 1.0mm, 350.0kHz, 7.4mm, 6.5mm, 2.5mm, 28.0A, 0) add(19.7mm, 1, 5, 1.5mm, 150.0kHz, 7.9mm, 7.9mm, 1.3mm, 16.0A, 1) add(29.5mm, 2, 1, 2.0mm, 350.0kHz, 3.8mm, 10.1mm, 2.2mm, 13.0A, 2) add(27.4mm, 1, 2, 3.0mm, 450.0kHz, 4.5mm, 7.6mm, 2.2mm, 1.0A, 4) add(21.1mm, 6, 1, 1.5mm, 450.0kHz, 12.8mm, 12.4mm, 1.9mm, 22.0A, 1) add(26.7mm, 3, 3, 1.5mm, 450.0kHz, 8.4mm, 7.4mm, 2.5mm, 22.0A, 1) add(28.8mm, 1, 9, 2.0mm, 450.0kHz, 14.2mm, 14.9mm, 3.4mm, 10.0A, 2) add(28.8mm, 1, 9, 1.0mm, 250.0kHz, 2.2mm, 7.2mm, 1.3mm, 4.0A, 0) add(29.5mm, 2, 3, 1.5mm, 150.0kHz, 7.0mm, 9.4mm, 1.9mm, 19.0A, 1) add(18.3mm, 7, 5, 1.0mm, 250.0kHz, 2.2mm, 10.4mm, 1.6mm, 10.0A, 0) add(23.2mm, 1, 8, 1.0mm, 350.0kHz, 9.7mm, 9.4mm, 1.6mm, 4.0A, 0) add(22.5mm, 8, 9, 2.0mm, 450.0kHz, 12.1mm, 8.6mm, 0.7mm, 1.0A, 2) add(27.4mm, 2, 3, 3.0mm, 150.0kHz, 13.3mm, 14.6mm, 2.5mm, 10.0A, 4) add(12.7mm, 8, 3, 1.5mm, 350.0kHz, 1.0mm, 5.7mm, 2.8mm, 25.0A, 1) add(21.8mm, 6, 5, 1.5mm, 350.0kHz, 9.6mm, 5.6mm, 3.1mm, 22.0A, 1) add(24.6mm, 10, 5, 1.5mm, 150.0kHz, 2.6mm, 11.1mm, 2.8mm, 10.0A, 1) add(28.8mm, 4, 9, 2.0mm, 450.0kHz, 14.2mm, 10.7mm, 2.2mm, 13.0A, 2) add(28.1mm, 3, 4, 1.0mm, 250.0kHz, 6.9mm, 13.3mm, 3.7mm, 4.0A, 0) add(26.7mm, 3, 2, 1.5mm, 450.0kHz, 10.0mm, 15.1mm, 1.9mm, 7.0A, 1) add(14.8mm, 3, 10, 1.5mm, 350.0kHz, 8.3mm, 5.4mm, 0.7mm, 1.0A, 1) add(21.8mm, 6, 3, 1.5mm, 450.0kHz, 12.8mm, 12.6mm, 3.1mm, 4.0A, 1) add(24.6mm, 1, 6, 1.5mm, 450.0kHz, 14.6mm, 13.2mm, 3.7mm, 7.0A, 1) add(28.8mm, 1, 2, 2.0mm, 250.0kHz, 9.4mm, 12.8mm, 3.7mm, 10.0A, 2) add(10.6mm, 2, 1, 2.0mm, 150.0kHz, 5.8mm, 3.8mm, 2.8mm, 25.0A, 2) add(14.8mm, 2, 1, 2.0mm, 450.0kHz, 4.3mm, 7.5mm, 2.5mm, 10.0A, 2) add(22.5mm, 7, 7, 1.5mm, 150.0kHz, 9.7mm, 6.5mm, 2.8mm, 10.0A, 1) add(26.7mm, 4, 4, 2.5mm, 350.0kHz, 9.2mm, 15.1mm, 3.7mm, 13.0A, 3) add(14.8mm, 7, 2, 1.0mm, 250.0kHz, 3.5mm, 8.2mm, 2.2mm, 10.0A, 0) add(7.8mm, 2, 3, 2.0mm, 250.0kHz, 1.8mm, 3.9mm, 2.2mm, 4.0A, 2) add(22.5mm, 8, 5, 1.0mm, 450.0kHz, 9.7mm, 13.5mm, 2.5mm, 7.0A, 0) add(28.8mm, 8, 7, 2.0mm, 350.0kHz, 5.4mm, 7.9mm, 2.2mm, 4.0A, 2) add(23.9mm, 9, 6, 1.5mm, 350.0kHz, 9.8mm, 13.8mm, 3.4mm, 4.0A, 1) add(29.5mm, 5, 4, 2.5mm, 350.0kHz, 13.4mm, 12.9mm, 2.2mm, 19.0A, 3) add(26.0mm, 2, 8, 1.0mm, 450.0kHz, 3.5mm, 6.5mm, 3.1mm, 1.0A, 0) add(19.7mm, 1, 4, 3.0mm, 250.0kHz, 2.3mm, 7.2mm, 0.7mm, 4.0A, 4) add(12.7mm, 5, 2, 1.5mm, 150.0kHz, 2.6mm, 3.6mm, 2.2mm, 22.0A, 1) add(26.7mm, 5, 4, 1.0mm, 450.0kHz, 13.2mm, 7.4mm, 2.5mm, 22.0A, 0) add(20.4mm, 9, 6, 1.0mm, 150.0kHz, 11.9mm, 8.1mm, 2.5mm, 1.0A, 0) add(26.0mm, 6, 4, 2.5mm, 250.0kHz, 9.9mm, 7.9mm, 3.4mm, 25.0A, 3)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
reports:
  L Table1: Matrix1.L(Winding1,Winding1), StrandedLossAC, CoreLoss vs Freq on Setup1 : LastAdaptive [dc1=all Nx=all Ny=all c=all f=all dc2=all ht=all lg1=all i=all mathindex=all N=all]

design Test1_501 (Maxwell 3D, EddyCurrent, model units mm)
variables:
  dc1 = 10mm
  Nx = 3
  Ny = 8
  c = 1mm
  f = 200kHz
  dc2 = 2.2mm
  ht = 3.1mm
  lg1 = 0.7mm
  i = 1A
  dwc = 0.7mm
  mathindex = index ArrayVarName='lizt_sweep' into 0
  N = 0
  lizt_sweep = ["copper_lizt_c_1", "copper_lizt_c_1.5", "copper_lizt_c_2", "copper_lizt_c_2.5", "copper_lizt_c_3", "copper_lizt_c_3.5", "copper_lizt_c_4", "copper_lizt_c_4.5", "copper_lizt_c_5"]
geometry:
  core_center = cylinder(axis=Z, base_centre=(0mm, 0mm, -lg1/4), radius=dc1/2, height=-(Ny*c/2+dwc))
  Box1 = box(corner=(-(dc1/2+2*dwc+Nx*c+dc2), dc1/2, -(Ny*c+2*dwc)/2), size=(2*(dc1/2+2*dwc+Nx*c+dc2), -dc1, -ht))
  Box2 = box(corner=(-(dc1/2+2*dwc+Nx*c+dc2), dc1/2, -(Ny*c+2*dwc)/2), size=(dc2, -dc1, (Ny*c+2*dwc)/2-lg1/4))
  Box2_1 = Box2.duplicate_mirror(point=(0mm, 0mm, 0mm), normal=(1mm, 0mm, 0mm))
  core_center.unite(Box1, Box2, Box2_1)
  core_center_1 [TDK_PC95_60cel_BH] = core_center.duplicate_mirror(point=(0mm, 0mm, 0mm), normal=(0mm, 0mm, 1mm))
  P [lizt_sweep[mathindex]] = rectangle(corner=(dc1/2+dwc, 0mm, -Ny*c/2), z_size=Ny*c, x_size=Nx*c)
  P.sweep_around_axis(axis=Z, angle=360deg)
  Region [vacuum] = region(percentage_offset: +X=100, -X=0, +Y=100, -Y=0, +Z=100, -Z=0)
  [core_center, core_center_1, P].split(plane=ZX, keep=PositiveOnly)
  [core_center, core_center_1, P].split(plane=YZ, keep=PositiveOnly)
  core_center.split(plane=XY, keep=PositiveOnly)
  core_center.delete()
  [core_center_1, P].split(plane=XY, keep=PositiveOnly)
boundaries and excitations:
  Symmetry1: Symmetry Faces=Region.face(-y, -x) IsOdd=true
  Symmetry2: Symmetry Faces=Region.face(-z) IsOdd=false
  CoilTerminal1: Coil Terminal Faces=P.face(at (7.2, 0, 2)) Conductor_number=Nx*Ny/2 Winding=Winding1 Point_out_of_terminal=false
  CoilTerminal2: Coil Terminal Faces=P.face(at (0, 7.2, 2)) Conductor_number=Nx*Ny/2 Winding=Winding1 Point_out_of_terminal=true
  Winding1: Winding Group Type=Current IsSolid=false Current=i ParallelBranchesNum=1 Phase=0deg
  eddy effects on: P
  core loss on: core_center_1
parameters:
  Matrix1: Matrix Winding1:
mesh:
  initial mesh: GlobalCurvilinear{Apply}
setups:
  Setup1: EddyCurrent MaximumPasses=10 MinimumPasses=2 MinimumConvergedPasses=1 PercentRefinement=60 PercentError=2 NonLinearResidual=0.0001 Frequency=f LossAdaptiveCtrl=0.5
optimetrics:
  sweep1: Parametric Sim._Setups=[Setup1]
    sweep dc2: 1.73mm
    sweep lg1: 0.7mm
    table edits: add(2.36mm, 0.8mm) add(3.06mm, 0.9mm) add(4mm, 1mm) add(5.34mm, 1.1mm) add(6mm, 1.15mm) add(7mm, 1.2mm)
output variables:
  k = 4*dc2/(3.14*dc1)
reports:
  L Plot1: Matrix1.L(Winding1,Winding1) vs k on Setup1 : LastAdaptive [Freq=all dc2=all lg1=all]
  Loss Plot1: CoreLoss, StrandedLossAC vs k on Setup1 : LastAdaptive [Freq=all dc2=all lg1=all]
  L Table1: Matrix1.L(Winding1,Winding1), CoreLoss, StrandedLossAC vs k on Setup1 : LastAdaptive [Freq=all dc2=all lg1=all]

design Test1_502 (Maxwell 3D, EddyCurrent, model units mm)
variables:
  dc1 = 11.4mm
  Nx = 6
  Ny = 4
  c = 1mm
  f = 200kHz
  dc2 = 4.6mm
  ht = 3.6mm
  lg1 = 1.4mm
  i = 1A
  dwc = 0.7mm
  mathindex = index ArrayVarName='lizt_sweep' into 0
  N = 0
  lizt_sweep = ["copper_lizt_c_1", "copper_lizt_c_1.5", "copper_lizt_c_2", "copper_lizt_c_2.5", "copper_lizt_c_3", "copper_lizt_c_3.5", "copper_lizt_c_4", "copper_lizt_c_4.5", "copper_lizt_c_5"]
geometry:
  core_center = cylinder(axis=Z, base_centre=(0mm, 0mm, -lg1/4), radius=dc1/2, height=-(Ny*c/2+dwc))
  Box1 = box(corner=(-(dc1/2+2*dwc+Nx*c+dc2), dc1/2, -(Ny*c+2*dwc)/2), size=(2*(dc1/2+2*dwc+Nx*c+dc2), -dc1, -ht))
  Box2 = box(corner=(-(dc1/2+2*dwc+Nx*c+dc2), dc1/2, -(Ny*c+2*dwc)/2), size=(dc2, -dc1, (Ny*c+2*dwc)/2-lg1/4))
  Box2_1 = Box2.duplicate_mirror(point=(0mm, 0mm, 0mm), normal=(1mm, 0mm, 0mm))
  core_center.unite(Box1, Box2, Box2_1)
  core_center_1 [TDK_PC95_60cel_BH] = core_center.duplicate_mirror(point=(0mm, 0mm, 0mm), normal=(0mm, 0mm, 1mm))
  P [lizt_sweep[mathindex]] = rectangle(corner=(dc1/2+dwc, 0mm, -Ny*c/2), z_size=Ny*c, x_size=Nx*c)
  P.sweep_around_axis(axis=Z, angle=360deg)
  Region [vacuum] = region(percentage_offset: +X=100, -X=0, +Y=100, -Y=0, +Z=100, -Z=0)
  [core_center, core_center_1, P].split(plane=ZX, keep=PositiveOnly)
  [core_center, core_center_1, P].split(plane=YZ, keep=PositiveOnly)
  core_center.split(plane=XY, keep=PositiveOnly)
  core_center.delete()
  [core_center_1, P].split(plane=XY, keep=PositiveOnly)
boundaries and excitations:
  Symmetry1: Symmetry Faces=Region.face(-y, -x) IsOdd=true
  Symmetry2: Symmetry Faces=Region.face(-z) IsOdd=false
  CoilTerminal1: Coil Terminal Faces=P.face(at (9.4, 0, 1)) Conductor_number=Nx*Ny/2 Winding=Winding1 Point_out_of_terminal=false
  CoilTerminal2: Coil Terminal Faces=P.face(at (0, 9.4, 1)) Conductor_number=Nx*Ny/2 Winding=Winding1 Point_out_of_terminal=true
  Winding1: Winding Group Type=Current IsSolid=false Current=i ParallelBranchesNum=1 Phase=0deg
  eddy effects on: P
  core loss on: core_center_1
parameters:
  Matrix1: Matrix Winding1:
mesh:
  initial mesh: GlobalCurvilinear{Apply}
setups:
  Setup1: EddyCurrent MaximumPasses=10 MinimumPasses=2 MinimumConvergedPasses=1 PercentRefinement=60 PercentError=2 NonLinearResidual=0.0001 Frequency=f LossAdaptiveCtrl=0.5
optimetrics:
  sweep_core1: Parametric Sim._Setups=[Setup1]
    sweep lg1: 0.95mm
    sweep dc2: 1.79mm
    table edits: add(1mm, 2.06mm) add(1.05mm, 2.33mm) add(1.1mm, 2.6mm) add(1.15mm, 2.95mm) add(1.2mm, 3.22mm) add(1.25mm, 3.58mm) add(1.3mm, 4.03mm) add(1.35mm, 4.47mm) add(1.4mm, 4.92mm) add(1.45mm, 5.46mm) add(1.5mm, 6.17mm) add(1.55mm, 6.71mm) add(1.6mm, 7.61mm) add(1.65mm, 8.14mm)
output variables:
  k = 4*dc2/(3.14*dc1)
reports:
  L Plot1: Matrix1.L(Winding1,Winding1) vs k on Setup1 : LastAdaptive [Freq=all dc2=all lg1=all]
  Loss Plot1: CoreLoss, StrandedLossAC vs k on Setup1 : LastAdaptive [Freq=all dc2=all lg1=all]
  L Table1: Matrix1.L(Winding1,Winding1), CoreLoss, StrandedLossAC vs k on Setup1 : LastAdaptive [Freq=all dc2=all lg1=all]

design Test1_503 (Maxwell 3D, EddyCurrent, model units mm)
variables:
  dc1 = 11.4mm
  Nx = 6
  Ny = 4
  c = 1mm
  f = 200kHz
  dc2 = 2.06mm
  ht = 3.6mm
  lg1 = 1.4mm
  i = 1.7A
  dwc = 0.7mm
  mathindex = index ArrayVarName='lizt_sweep' into 0
  N = 0
  lizt_sweep = ["copper_lizt_c_1", "copper_lizt_c_1.5", "copper_lizt_c_2", "copper_lizt_c_2.5", "copper_lizt_c_3", "copper_lizt_c_3.5", "copper_lizt_c_4", "copper_lizt_c_4.5", "copper_lizt_c_5"]
geometry:
  core_center = cylinder(axis=Z, base_centre=(0mm, 0mm, -lg1/4), radius=dc1/2, height=-(Ny*c/2+dwc))
  Box1 = box(corner=(-(dc1/2+2*dwc+Nx*c+dc2), dc1/2, -(Ny*c+2*dwc)/2), size=(2*(dc1/2+2*dwc+Nx*c+dc2), -dc1, -ht))
  Box2 = box(corner=(-(dc1/2+2*dwc+Nx*c+dc2), dc1/2, -(Ny*c+2*dwc)/2), size=(dc2, -dc1, (Ny*c+2*dwc)/2-lg1/4))
  Box2_1 = Box2.duplicate_mirror(point=(0mm, 0mm, 0mm), normal=(1mm, 0mm, 0mm))
  core_center.unite(Box1, Box2, Box2_1)
  core_center_1 [TDK_PC95_60cel_BH] = core_center.duplicate_mirror(point=(0mm, 0mm, 0mm), normal=(0mm, 0mm, 1mm))
  P [lizt_sweep[mathindex]] = rectangle(corner=(dc1/2+dwc, 0mm, -Ny*c/2), z_size=Ny*c, x_size=Nx*c)
  P.sweep_around_axis(axis=Z, angle=360deg)
  Region [vacuum] = region(percentage_offset: +X=100, -X=0, +Y=100, -Y=0, +Z=100, -Z=0)
  [core_center, core_center_1, P].split(plane=ZX, keep=PositiveOnly)
  [core_center, core_center_1, P].split(plane=YZ, keep=PositiveOnly)
  core_center.split(plane=XY, keep=PositiveOnly)
  core_center.delete()
  [core_center_1, P].split(plane=XY, keep=PositiveOnly)
boundaries and excitations:
  Symmetry1: Symmetry Faces=Region.face(-y, -x) IsOdd=true
  Symmetry2: Symmetry Faces=Region.face(-z) IsOdd=false
  CoilTerminal1: Coil Terminal Faces=P.face(at (9.4, 0, 1)) Conductor_number=Nx*Ny/2 Winding=Winding1 Point_out_of_terminal=false
  CoilTerminal2: Coil Terminal Faces=P.face(at (0, 9.4, 1)) Conductor_number=Nx*Ny/2 Winding=Winding1 Point_out_of_terminal=true
  Winding1: Winding Group Type=Current IsSolid=false Current=i ParallelBranchesNum=1 Phase=0deg
  eddy effects on: P
  core loss on: core_center_1
parameters:
  Matrix1: Matrix Winding1:
mesh:
  initial mesh: GlobalCurvilinear{Apply}
setups:
  Setup1: EddyCurrent MaximumPasses=10 MinimumPasses=2 MinimumConvergedPasses=1 PercentRefinement=60 PercentError=2 NonLinearResidual=0.0001 Frequency=f LossAdaptiveCtrl=0.5
optimetrics:
  sweep_core3_1_7A1: Parametric Sim._Setups=[Setup1]
    sweep lg1: 0.95mm
    sweep dc2: 1.79mm
    table edits: add(1mm, 2.06mm) add(1.05mm, 2.33mm) add(1.1mm, 2.6mm) add(1.15mm, 2.86mm) add(1.2mm, 3.22mm) add(1.25mm, 3.58mm) add(1.3mm, 4.03mm) add(1.35mm, 4.47mm) add(1.4mm, 4.92mm) add(1.45mm, 5.46mm) add(1.5mm, 6.17mm) add(1.55mm, 6.71mm) add(1.6mm, 7.52mm) add(1.65mm, 8.14mm)
output variables:
  k = 4*dc2/(3.14*dc1)
reports:
  L Plot1: Matrix1.L(Winding1,Winding1) vs k on Setup1 : LastAdaptive [Freq=all dc2=all lg1=all]
  Loss Plot1: CoreLoss, StrandedLossAC vs k on Setup1 : LastAdaptive [Freq=all dc2=all lg1=all]
  L Table1: Matrix1.L(Winding1,Winding1), CoreLoss, StrandedLossAC vs k on Setup1 : LastAdaptive [Freq=all dc2=all lg1=all]
